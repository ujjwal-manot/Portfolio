* 10 GBd clocked regenerative StrongARM sampler with RS NOR output latch on IHP SG13G2 low-voltage devices: precharges internal nodes high when clk is low, regenerates differential input when clk rises, and holds outp/outn across the UI; sizes from sampler_sizes.inc.
.subckt sampler inp inn clk outp outn vdd vss
XMT tail clk vss vss sg13_lv_nmos w={w_tail} l={l_min} ng=8 mm_ok={mm}
XM1 dn inp tail vss sg13_lv_nmos w={w_inp} l={l_min} ng={ng_in} mm_ok={mm}
XM2 dp inn tail vss sg13_lv_nmos w={w_inn} l={l_min} ng={ng_in} mm_ok={mm}
XM3 an ap dn vss sg13_lv_nmos w={w_nx} l={l_min} ng=4 mm_ok={mm}
XM4 ap an dp vss sg13_lv_nmos w={w_nx} l={l_min} ng=4 mm_ok={mm}
XM5 an ap vdd vdd sg13_lv_pmos w={w_px} l={l_min} ng=4 mm_ok={mm}
XM6 ap an vdd vdd sg13_lv_pmos w={w_px} l={l_min} ng=4 mm_ok={mm}
XR1 an clk vdd vdd sg13_lv_pmos w={w_rst} l={l_min} ng=2 mm_ok={mm}
XR2 ap clk vdd vdd sg13_lv_pmos w={w_rst} l={l_min} ng=2 mm_ok={mm}
XR3 dn clk vdd vdd sg13_lv_pmos w={w_rst} l={l_min} ng=2 mm_ok={mm}
XR4 dp clk vdd vdd sg13_lv_pmos w={w_rst} l={l_min} ng=2 mm_ok={mm}
XIN bn an vdd vss smp_inv
XIP bp ap vdd vss smp_inv
XLP outp bp outn vdd vss smp_nor2
XLN outn bn outp vdd vss smp_nor2
.ends sampler
.subckt smp_inv y a vdd vss
XP y a vdd vdd sg13_lv_pmos w={w_inv_p} l={l_min} ng=2 mm_ok={mm}
XN y a vss vss sg13_lv_nmos w={w_inv_n} l={l_min} ng=1 mm_ok={mm}
.ends smp_inv
.subckt smp_nor2 y a b vdd vss
XPA m a vdd vdd sg13_lv_pmos w={w_inv_p} l={l_min} ng=2 mm_ok={mm}
XPB y b m vdd sg13_lv_pmos w={w_inv_p} l={l_min} ng=2 mm_ok={mm}
XNA y a vss vss sg13_lv_nmos w={w_inv_n} l={l_min} ng=1 mm_ok={mm}
XNB y b vss vss sg13_lv_nmos w={w_inv_n} l={l_min} ng=1 mm_ok={mm}
.ends smp_nor2

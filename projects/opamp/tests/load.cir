* Runs the opamp's inverting loop (output at 1.0 V) into the ADC's real capacitor DAC (projects/adc/design/cap_dac.cir, listed in uses.txt) instead of a fixed capacitor, and writes to load.txt the output noise integrated from 1 Hz to 10 GHz at the MSB bottom plate (node xdac.xc.xb7.b, inside the DAC's calibrated core; the run is written as nan unless that node follows the output within 1 mV while sampling at 0.45 us, so a renamed node that ngspice would silently create at 0 V cannot pass) with the DAC sampling (so the sampling switches' own band limit and thermal noise count), and the settling error (against the output's settled value at 0.99 us, with the DAC switched away) at the end of the 200 ns sampling window that starts at 2 us and 50 ns into it, and how far the output dips, when the bottom plates, parked at vref_lo since 0.5 us, are switched back onto the output (the worst kick: 0.8 V across 2.05 pF); samp is high from time 0 to 0.5 us so the top plate is tied to vcmd at the transient's operating point (with samp low it floats and the operating point fails at cold and fast corners), the settling errors are measured on the bottom plate and output less the rounded settled value, so a meas's 7-digit rounding sets no 1 uV floor; and every value is written as nan if any measurement failed (a failed measure leaves its vector undefined, so the sum of the measures times zero cannot be formed); corner, temperature and supply come from corner.inc, the opamp from dut.cir and sizes.inc.
.include corner.inc
.include sizes.inc
.include dut.cir
.include cap_dac_sizes.inc
.include cap_dac.cir
.option reltol=1e-5 vntol=1e-8
VDD vdd 0 dc {vsupply} ac 0
VCM inp 0 0.6
VIN in 0 dc 0.2 ac 1
IB vdd ibias 10u
XRIN in inn 0 rhigh w={w_rf} l={l_rf} mm_ok={mm}
XRF inn out 0 rhigh w={w_rf} l={l_rf} mm_ok={mm}
XOP inp inn out vdd 0 ibias opamp
VHI vref_hi 0 1.0
VLO vref_lo 0 0.2
VCMD vcmd 0 0.6
VSAMP samp 0 dc {vsupply} pwl(0 {vsupply} 0.5u {vsupply} 0.50005u 0 2u 0 2.00005u {vsupply} 2.2u {vsupply} 2.20005u 0)
XDAC top out vcmd vref_hi vref_lo samp 0 0 0 0 0 0 0 0 vdd 0 cap_dac
.control
noise v(xdac.xc.xb7.b) VIN dec 20 1 10g
tran 0.1n 2.25u
let sampled = noise2.onoise_total
meas tran target find v(out) at=0.99u
let platediff = v(xdac.xc.xb7.b) - target
let outdiff = v(out) - target
meas tran got find platediff at=2.199u
meas tran early find platediff at=2.05u
meas tran settled find outdiff at=0.99u
meas tran dip min v(out) from=2u to=2.2u
meas tran plate0 find v(xdac.xc.xb7.b) at=0.45u
meas tran out0 find v(out) at=0.45u
let error = abs(got - settled)
let error50 = abs(early - settled)
let kick = target - dip
let complete = sampled*0 + target*0 + got*0 + early*0 + settled*0 + dip*0 + (abs(plate0 - out0) > 1e-3)
if complete = 0
  echo load sampled_v_rms $&sampled settle_load_v $&error error_at_50ns_v $&error50 kick_v $&kick > load.txt
else
  echo load sampled_v_rms nan settle_load_v nan error_at_50ns_v nan kick_v nan > load.txt
end
quit
.endc
.end

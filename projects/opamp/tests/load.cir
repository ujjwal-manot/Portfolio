* Runs the opamp's inverting loop (output at 1.0 V) into the ADC's real capacitor DAC (projects/adc/design/cap_dac.cir, listed in uses.txt) instead of a fixed capacitor, and writes to load.txt the output noise integrated from 1 Hz to 10 GHz at the MSB bottom plate with the DAC sampling (so the sampling switches' own band limit and thermal noise count), and the settling error (against the output's settled value before the first window) at the end of a 200 ns sampling window and 50 ns into it, and how far the output dips, when the bottom plates, parked at vref_lo between samples, are switched back onto the output (the worst kick: 0.8 V across 2.05 pF); corner, temperature and supply come from corner.inc, the opamp from dut.cir and sizes.inc.
.include corner.inc
.include sizes.inc
.include dut.cir
.include cap_dac_sizes.inc
.include cap_dac.cir
.option reltol=1e-5 vntol=1e-8
VDD vdd 0 dc {vsupply} ac 0
VCM inp 0 0.6
VIN in 0 dc 0.2 ac 1
IB vdd ibias 10u
XRIN in inn 0 rhigh w={w_rf} l={l_rf} mm_ok={mm}
XRF inn out 0 rhigh w={w_rf} l={l_rf} mm_ok={mm}
XOP inp inn out vdd 0 ibias opamp
VHI vref_hi 0 1.0
VLO vref_lo 0 0.2
VCMD vcmd 0 0.6
VSAMP samp 0 dc {vsupply} pulse(0 {vsupply} 1u 50p 50p 200n 1u)
XDAC top out vcmd vref_hi vref_lo samp 0 0 0 0 0 0 0 0 vdd 0 cap_dac
.control
let sampled = 0
let error = 0
let error50 = 0
let kick = 0
noise v(xdac.xb7.b) VIN dec 20 1 10g
let sampled = noise2.onoise_total
tran 0.1n 2.25u
meas tran target find v(out) at=0.99u
meas tran got find v(xdac.xb7.b) at=2.199u
meas tran early find v(xdac.xb7.b) at=2.05u
meas tran dip min v(out) from=2u to=2.2u
let error = abs(got - target)
let error50 = abs(early - target)
let kick = target - dip
echo load sampled_v_rms $&sampled settle_load_v $&error error_at_50ns_v $&error50 kick_v $&kick > load.txt
quit
.endc
.end

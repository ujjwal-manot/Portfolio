* Runs the real inverting loop (input and inp at 0.6 V) for output noise, integrated over the 50 kHz signal band and over 1 Hz to 1 GHz (all of it reaches the sampling ADC), and for supply rejection (gain from input over gain from vdd) at 1 kHz and 1 MHz, writing them to noise.txt; corner, temperature and supply come from corner.inc, the opamp from dut.cir and sizes.inc; every value is written as nan if any measurement or analysis failed.
.include corner.inc
.include sizes.inc
.include dut.cir
VDD vdd 0 dc {vsupply} ac 0
VCM inp 0 0.6
VIN in 0 dc 0.6 ac 1
IB vdd ibias 10u
XRIN in inn 0 rhigh w={w_rf} l={l_rf} mm_ok={mm}
XRF inn out 0 rhigh w={w_rf} l={l_rf} mm_ok={mm}
XCL out 0 cap_cmim w={w_cl} l={l_cl} mm_ok={mm}
XOP inp inn out vdd 0 ibias opamp
.control
let band = 1e30
let total = 1e30
let g1k = 1e30
let g1m = 1e30
let s1k = 1e30
let s1m = 1e30
let points = 1e30
noise v(out) VIN dec 20 1 1g
let total = noise2.onoise_total
noise v(out) VIN dec 20 1 50k
let band = noise4.onoise_total
ac dec 20 1 10meg
let points = length(frequency)
meas ac g1k find vdb(out) at=1e3
meas ac g1m find vdb(out) at=1e6
alter VIN ac = 0
alter VDD ac = 1
ac dec 20 1 10meg
meas ac s1k find vdb(out) at=1e3
meas ac s1m find vdb(out) at=1e6
let psrr1k = g1k - s1k
let psrr1m = g1m - s1m
let failed = (band > 1e29) + (total > 1e29) + (g1k > 1e29) + (g1m > 1e29) + (s1k > 1e29) + (s1m > 1e29) + (points > 1e29)
if failed > 0
  echo noise band_v_rms nan total_v_rms nan psrr_1k_db nan psrr_1m_db nan > noise.txt
else
  echo noise band_v_rms $&band total_v_rms $&total psrr_1k_db $&psrr1k psrr_1m_db $&psrr1m > noise.txt
end
quit
.endc
.end

* Sweeps the input of the real inverting loop from 0 to 1.2 V and writes the output range over which the output stays within half an LSB (1.5625 mV) of 1.2 V minus the input, after removing the error at mid-scale, to swing.txt; corner, temperature and supply come from corner.inc, the opamp from dut.cir and sizes.inc.
.include corner.inc
.include sizes.inc
.include dut.cir
VDD vdd 0 {vsupply}
VCM inp 0 0.6
VIN in 0 0.6
IB vdd ibias 10u
XRIN in inn 0 rhigh w={w_rf} l={l_rf}
XRF inn out 0 rhigh w={w_rf} l={l_rf}
XCL out 0 cap_cmim w={w_cl} l={l_cl}
XOP inp inn out vdd 0 ibias opamp
.control
let mid = 0
let lo = -1
let hi = -1
dc VIN 0 1.2 1m
meas dc mid find v(out) at=0.6
let err = abs(v(out) - mid - (0.6 - v(in)))
meas dc hi when err=1.5625m cross=1
meas dc lo when err=1.5625m cross=last
let out_high = mid + 0.6 - hi
let out_low = mid + 0.6 - lo
echo swing out_low_v $&out_low out_high_v $&out_high > swing.txt
quit
.endc
.end

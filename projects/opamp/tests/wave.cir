* Runs the real inverting loop (rhigh Rin = Rf = 20 k, MIM 2.05 pF load) through the 0.8 V steps of step.cir (input 1.0 to 0.2 V at 50 ns and back at 450 ns, the fit stimulus of the real-number model) and then a staircase of output steps of +0.05, +0.2, +0.4, -0.55, +0.7, -0.4 and +0.02 V every 400 ns from 850 ns (the validation stimulus), all with 1 ns edges, and writes time, input and output to wave.txt for helpers/opamp_model.py; corner, temperature and supply come from corner.inc, the opamp from dut.cir and sizes.inc.
.include corner.inc
.include sizes.inc
.include dut.cir
VDD vdd 0 {vsupply}
VCM inp 0 0.6
VIN in 0 pwl(0 1.0 50n 1.0 51n 0.2 450n 0.2 451n 1.0 850n 1.0 851n 0.95 1250n 0.95 1251n 0.75 1650n 0.75 1651n 0.35 2050n 0.35 2051n 0.9 2450n 0.9 2451n 0.2 2850n 0.2 2851n 0.6 3250n 0.6 3251n 0.58)
IB vdd ibias 10u
XRIN in inn 0 rhigh w={w_rf} l={l_rf} mm_ok={mm}
XRF inn out 0 rhigh w={w_rf} l={l_rf} mm_ok={mm}
XCL out 0 cap_cmim w={w_cl} l={l_cl} mm_ok={mm}
XOP inp inn out vdd 0 ibias opamp
.control
tran 0.1n 3650n
wrdata wave.txt v(in) v(out)
quit
.endc
.end

* Folded-cascode two-stage Miller opamp on IHP SG13G2 low-voltage devices: NMOS input pair folded into PMOS cascodes over a low-voltage NMOS cascode mirror, PMOS common-source output, MIM Miller capacitor with an rhigh nulling resistor, all biased from the 10 uA ibias sink; sizes come from sizes.inc, written by helpers/opamp_sizing.py.
.subckt opamp inp inn out vdd vss ibias
XMB0 ibias ibias vss vss sg13_lv_nmos w={w_nu} l={l_nu} ng={ng_nu} m={m_ref}
XMBN1 vbp ibias vss vss sg13_lv_nmos w={w_nu} l={l_nu} ng={ng_nu} m=1
XMBP vbp vbp vdd vdd sg13_lv_pmos w={w_pu} l={l_pu} ng={ng_pu} m=1
XMBN2 vbpc ibias vss vss sg13_lv_nmos w={w_nu} l={l_nu} ng={ng_nu} m=1
XMBPC vbpc vbpc vdd vdd sg13_lv_pmos w={w_bpc} l={l_pu} ng={ng_bpc} m=1
XMBP2 vbnc vbp vdd vdd sg13_lv_pmos w={w_pu} l={l_pu} ng={ng_pu} m=1
XMBNC vbnc vbnc vss vss sg13_lv_nmos w={w_bnc} l={l_nu} ng={ng_bnc} m=1
XM5 t ibias vss vss sg13_lv_nmos w={w_nu} l={l_nu} ng={ng_nu} m={m_tail}
XM1 f1 inn t vss sg13_lv_nmos w={w_in} l={l_in} ng={ng_in}
XM2 f2 inp t vss sg13_lv_nmos w={w_in} l={l_in} ng={ng_in}
XM3 f1 vbp vdd vdd sg13_lv_pmos w={w_pu} l={l_pu} ng={ng_pu} m={m_fold}
XM4 f2 vbp vdd vdd sg13_lv_pmos w={w_pu} l={l_pu} ng={ng_pu} m={m_fold}
XM3C x vbpc f1 vdd sg13_lv_pmos w={w_pcas} l={l_pcas} ng={ng_pcas}
XM4C o1 vbpc f2 vdd sg13_lv_pmos w={w_pcas} l={l_pcas} ng={ng_pcas}
XM6C x vbnc n1 vss sg13_lv_nmos w={w_ncas} l={l_ncas} ng={ng_ncas}
XM7C o1 vbnc n2 vss sg13_lv_nmos w={w_ncas} l={l_ncas} ng={ng_ncas}
XM6 n1 x vss vss sg13_lv_nmos w={w_bot} l={l_bot} ng={ng_bot}
XM7 n2 x vss vss sg13_lv_nmos w={w_bot} l={l_bot} ng={ng_bot}
XM8 out o1 vdd vdd sg13_lv_pmos w={w_out} l={l_out} ng={ng_out}
XM9 out ibias vss vss sg13_lv_nmos w={w_nu} l={l_nu} ng={ng_nu} m={m_sink}
XRZ o1 cz vss rhigh w={w_rz} l={l_rz}
XCC cz out cap_cmim w={w_cc} l={l_cc}
.ends opamp

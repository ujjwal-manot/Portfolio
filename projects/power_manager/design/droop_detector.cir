* Droop detector: on every rising clk edge the edge runs down two chains of IHP inv_1 cells, a reference chain of 40 on the fixed vdd_mem rail (each loaded by the next stage and one spare inv_1 input) and a measuring chain of 64 on vdd_cpu (each loaded by the next stage and one latch input); when the edge leaves the reference chain an inv_8 closes 64 dlhq_1 latches on vdd_mem that were following every measuring tap, so they hold how far the edge got (tap k reached when q_k is 1 for even k and 0 for odd k) until the falling edge reopens them half a clock later; the code, the number of taps reached, is the ratio of the two rails' gate delays and falls as vdd_cpu sags; the latches sit on vdd_mem so the code lands in the clock logic's domain without a level shifter.
.subckt droop_detector clk q1 q2 q3 q4 q5 q6 q7 q8 q9 q10 q11 q12 q13 q14 q15 q16 q17 q18 q19 q20 q21 q22 q23 q24 q25 q26 q27 q28 q29 q30 q31 q32 q33 q34 q35 q36 q37 q38 q39 q40 q41 q42 q43 q44 q45 q46 q47 q48 q49 q50 q51 q52 q53 q54 q55 q56 q57 q58 q59 q60 q61 q62 q63 q64 vdd_cpu vdd_mem vss
XR1 r1 clk vdd_mem vss sg13g2_inv_1
XRL1 rl1 r1 vdd_mem vss sg13g2_inv_1
XR2 r2 r1 vdd_mem vss sg13g2_inv_1
XRL2 rl2 r2 vdd_mem vss sg13g2_inv_1
XR3 r3 r2 vdd_mem vss sg13g2_inv_1
XRL3 rl3 r3 vdd_mem vss sg13g2_inv_1
XR4 r4 r3 vdd_mem vss sg13g2_inv_1
XRL4 rl4 r4 vdd_mem vss sg13g2_inv_1
XR5 r5 r4 vdd_mem vss sg13g2_inv_1
XRL5 rl5 r5 vdd_mem vss sg13g2_inv_1
XR6 r6 r5 vdd_mem vss sg13g2_inv_1
XRL6 rl6 r6 vdd_mem vss sg13g2_inv_1
XR7 r7 r6 vdd_mem vss sg13g2_inv_1
XRL7 rl7 r7 vdd_mem vss sg13g2_inv_1
XR8 r8 r7 vdd_mem vss sg13g2_inv_1
XRL8 rl8 r8 vdd_mem vss sg13g2_inv_1
XR9 r9 r8 vdd_mem vss sg13g2_inv_1
XRL9 rl9 r9 vdd_mem vss sg13g2_inv_1
XR10 r10 r9 vdd_mem vss sg13g2_inv_1
XRL10 rl10 r10 vdd_mem vss sg13g2_inv_1
XR11 r11 r10 vdd_mem vss sg13g2_inv_1
XRL11 rl11 r11 vdd_mem vss sg13g2_inv_1
XR12 r12 r11 vdd_mem vss sg13g2_inv_1
XRL12 rl12 r12 vdd_mem vss sg13g2_inv_1
XR13 r13 r12 vdd_mem vss sg13g2_inv_1
XRL13 rl13 r13 vdd_mem vss sg13g2_inv_1
XR14 r14 r13 vdd_mem vss sg13g2_inv_1
XRL14 rl14 r14 vdd_mem vss sg13g2_inv_1
XR15 r15 r14 vdd_mem vss sg13g2_inv_1
XRL15 rl15 r15 vdd_mem vss sg13g2_inv_1
XR16 r16 r15 vdd_mem vss sg13g2_inv_1
XRL16 rl16 r16 vdd_mem vss sg13g2_inv_1
XR17 r17 r16 vdd_mem vss sg13g2_inv_1
XRL17 rl17 r17 vdd_mem vss sg13g2_inv_1
XR18 r18 r17 vdd_mem vss sg13g2_inv_1
XRL18 rl18 r18 vdd_mem vss sg13g2_inv_1
XR19 r19 r18 vdd_mem vss sg13g2_inv_1
XRL19 rl19 r19 vdd_mem vss sg13g2_inv_1
XR20 r20 r19 vdd_mem vss sg13g2_inv_1
XRL20 rl20 r20 vdd_mem vss sg13g2_inv_1
XR21 r21 r20 vdd_mem vss sg13g2_inv_1
XRL21 rl21 r21 vdd_mem vss sg13g2_inv_1
XR22 r22 r21 vdd_mem vss sg13g2_inv_1
XRL22 rl22 r22 vdd_mem vss sg13g2_inv_1
XR23 r23 r22 vdd_mem vss sg13g2_inv_1
XRL23 rl23 r23 vdd_mem vss sg13g2_inv_1
XR24 r24 r23 vdd_mem vss sg13g2_inv_1
XRL24 rl24 r24 vdd_mem vss sg13g2_inv_1
XR25 r25 r24 vdd_mem vss sg13g2_inv_1
XRL25 rl25 r25 vdd_mem vss sg13g2_inv_1
XR26 r26 r25 vdd_mem vss sg13g2_inv_1
XRL26 rl26 r26 vdd_mem vss sg13g2_inv_1
XR27 r27 r26 vdd_mem vss sg13g2_inv_1
XRL27 rl27 r27 vdd_mem vss sg13g2_inv_1
XR28 r28 r27 vdd_mem vss sg13g2_inv_1
XRL28 rl28 r28 vdd_mem vss sg13g2_inv_1
XR29 r29 r28 vdd_mem vss sg13g2_inv_1
XRL29 rl29 r29 vdd_mem vss sg13g2_inv_1
XR30 r30 r29 vdd_mem vss sg13g2_inv_1
XRL30 rl30 r30 vdd_mem vss sg13g2_inv_1
XR31 r31 r30 vdd_mem vss sg13g2_inv_1
XRL31 rl31 r31 vdd_mem vss sg13g2_inv_1
XR32 r32 r31 vdd_mem vss sg13g2_inv_1
XRL32 rl32 r32 vdd_mem vss sg13g2_inv_1
XR33 r33 r32 vdd_mem vss sg13g2_inv_1
XRL33 rl33 r33 vdd_mem vss sg13g2_inv_1
XR34 r34 r33 vdd_mem vss sg13g2_inv_1
XRL34 rl34 r34 vdd_mem vss sg13g2_inv_1
XR35 r35 r34 vdd_mem vss sg13g2_inv_1
XRL35 rl35 r35 vdd_mem vss sg13g2_inv_1
XR36 r36 r35 vdd_mem vss sg13g2_inv_1
XRL36 rl36 r36 vdd_mem vss sg13g2_inv_1
XR37 r37 r36 vdd_mem vss sg13g2_inv_1
XRL37 rl37 r37 vdd_mem vss sg13g2_inv_1
XR38 r38 r37 vdd_mem vss sg13g2_inv_1
XRL38 rl38 r38 vdd_mem vss sg13g2_inv_1
XR39 r39 r38 vdd_mem vss sg13g2_inv_1
XRL39 rl39 r39 vdd_mem vss sg13g2_inv_1
XR40 r40 r39 vdd_mem vss sg13g2_inv_1
XRL40 rl40 r40 vdd_mem vss sg13g2_inv_1
XG gate r40 vdd_mem vss sg13g2_inv_8
XM1 t1 clk vdd_cpu vss sg13g2_inv_1
XL1 q1 t1 gate vdd_mem vss sg13g2_dlhq_1
XM2 t2 t1 vdd_cpu vss sg13g2_inv_1
XL2 q2 t2 gate vdd_mem vss sg13g2_dlhq_1
XM3 t3 t2 vdd_cpu vss sg13g2_inv_1
XL3 q3 t3 gate vdd_mem vss sg13g2_dlhq_1
XM4 t4 t3 vdd_cpu vss sg13g2_inv_1
XL4 q4 t4 gate vdd_mem vss sg13g2_dlhq_1
XM5 t5 t4 vdd_cpu vss sg13g2_inv_1
XL5 q5 t5 gate vdd_mem vss sg13g2_dlhq_1
XM6 t6 t5 vdd_cpu vss sg13g2_inv_1
XL6 q6 t6 gate vdd_mem vss sg13g2_dlhq_1
XM7 t7 t6 vdd_cpu vss sg13g2_inv_1
XL7 q7 t7 gate vdd_mem vss sg13g2_dlhq_1
XM8 t8 t7 vdd_cpu vss sg13g2_inv_1
XL8 q8 t8 gate vdd_mem vss sg13g2_dlhq_1
XM9 t9 t8 vdd_cpu vss sg13g2_inv_1
XL9 q9 t9 gate vdd_mem vss sg13g2_dlhq_1
XM10 t10 t9 vdd_cpu vss sg13g2_inv_1
XL10 q10 t10 gate vdd_mem vss sg13g2_dlhq_1
XM11 t11 t10 vdd_cpu vss sg13g2_inv_1
XL11 q11 t11 gate vdd_mem vss sg13g2_dlhq_1
XM12 t12 t11 vdd_cpu vss sg13g2_inv_1
XL12 q12 t12 gate vdd_mem vss sg13g2_dlhq_1
XM13 t13 t12 vdd_cpu vss sg13g2_inv_1
XL13 q13 t13 gate vdd_mem vss sg13g2_dlhq_1
XM14 t14 t13 vdd_cpu vss sg13g2_inv_1
XL14 q14 t14 gate vdd_mem vss sg13g2_dlhq_1
XM15 t15 t14 vdd_cpu vss sg13g2_inv_1
XL15 q15 t15 gate vdd_mem vss sg13g2_dlhq_1
XM16 t16 t15 vdd_cpu vss sg13g2_inv_1
XL16 q16 t16 gate vdd_mem vss sg13g2_dlhq_1
XM17 t17 t16 vdd_cpu vss sg13g2_inv_1
XL17 q17 t17 gate vdd_mem vss sg13g2_dlhq_1
XM18 t18 t17 vdd_cpu vss sg13g2_inv_1
XL18 q18 t18 gate vdd_mem vss sg13g2_dlhq_1
XM19 t19 t18 vdd_cpu vss sg13g2_inv_1
XL19 q19 t19 gate vdd_mem vss sg13g2_dlhq_1
XM20 t20 t19 vdd_cpu vss sg13g2_inv_1
XL20 q20 t20 gate vdd_mem vss sg13g2_dlhq_1
XM21 t21 t20 vdd_cpu vss sg13g2_inv_1
XL21 q21 t21 gate vdd_mem vss sg13g2_dlhq_1
XM22 t22 t21 vdd_cpu vss sg13g2_inv_1
XL22 q22 t22 gate vdd_mem vss sg13g2_dlhq_1
XM23 t23 t22 vdd_cpu vss sg13g2_inv_1
XL23 q23 t23 gate vdd_mem vss sg13g2_dlhq_1
XM24 t24 t23 vdd_cpu vss sg13g2_inv_1
XL24 q24 t24 gate vdd_mem vss sg13g2_dlhq_1
XM25 t25 t24 vdd_cpu vss sg13g2_inv_1
XL25 q25 t25 gate vdd_mem vss sg13g2_dlhq_1
XM26 t26 t25 vdd_cpu vss sg13g2_inv_1
XL26 q26 t26 gate vdd_mem vss sg13g2_dlhq_1
XM27 t27 t26 vdd_cpu vss sg13g2_inv_1
XL27 q27 t27 gate vdd_mem vss sg13g2_dlhq_1
XM28 t28 t27 vdd_cpu vss sg13g2_inv_1
XL28 q28 t28 gate vdd_mem vss sg13g2_dlhq_1
XM29 t29 t28 vdd_cpu vss sg13g2_inv_1
XL29 q29 t29 gate vdd_mem vss sg13g2_dlhq_1
XM30 t30 t29 vdd_cpu vss sg13g2_inv_1
XL30 q30 t30 gate vdd_mem vss sg13g2_dlhq_1
XM31 t31 t30 vdd_cpu vss sg13g2_inv_1
XL31 q31 t31 gate vdd_mem vss sg13g2_dlhq_1
XM32 t32 t31 vdd_cpu vss sg13g2_inv_1
XL32 q32 t32 gate vdd_mem vss sg13g2_dlhq_1
XM33 t33 t32 vdd_cpu vss sg13g2_inv_1
XL33 q33 t33 gate vdd_mem vss sg13g2_dlhq_1
XM34 t34 t33 vdd_cpu vss sg13g2_inv_1
XL34 q34 t34 gate vdd_mem vss sg13g2_dlhq_1
XM35 t35 t34 vdd_cpu vss sg13g2_inv_1
XL35 q35 t35 gate vdd_mem vss sg13g2_dlhq_1
XM36 t36 t35 vdd_cpu vss sg13g2_inv_1
XL36 q36 t36 gate vdd_mem vss sg13g2_dlhq_1
XM37 t37 t36 vdd_cpu vss sg13g2_inv_1
XL37 q37 t37 gate vdd_mem vss sg13g2_dlhq_1
XM38 t38 t37 vdd_cpu vss sg13g2_inv_1
XL38 q38 t38 gate vdd_mem vss sg13g2_dlhq_1
XM39 t39 t38 vdd_cpu vss sg13g2_inv_1
XL39 q39 t39 gate vdd_mem vss sg13g2_dlhq_1
XM40 t40 t39 vdd_cpu vss sg13g2_inv_1
XL40 q40 t40 gate vdd_mem vss sg13g2_dlhq_1
XM41 t41 t40 vdd_cpu vss sg13g2_inv_1
XL41 q41 t41 gate vdd_mem vss sg13g2_dlhq_1
XM42 t42 t41 vdd_cpu vss sg13g2_inv_1
XL42 q42 t42 gate vdd_mem vss sg13g2_dlhq_1
XM43 t43 t42 vdd_cpu vss sg13g2_inv_1
XL43 q43 t43 gate vdd_mem vss sg13g2_dlhq_1
XM44 t44 t43 vdd_cpu vss sg13g2_inv_1
XL44 q44 t44 gate vdd_mem vss sg13g2_dlhq_1
XM45 t45 t44 vdd_cpu vss sg13g2_inv_1
XL45 q45 t45 gate vdd_mem vss sg13g2_dlhq_1
XM46 t46 t45 vdd_cpu vss sg13g2_inv_1
XL46 q46 t46 gate vdd_mem vss sg13g2_dlhq_1
XM47 t47 t46 vdd_cpu vss sg13g2_inv_1
XL47 q47 t47 gate vdd_mem vss sg13g2_dlhq_1
XM48 t48 t47 vdd_cpu vss sg13g2_inv_1
XL48 q48 t48 gate vdd_mem vss sg13g2_dlhq_1
XM49 t49 t48 vdd_cpu vss sg13g2_inv_1
XL49 q49 t49 gate vdd_mem vss sg13g2_dlhq_1
XM50 t50 t49 vdd_cpu vss sg13g2_inv_1
XL50 q50 t50 gate vdd_mem vss sg13g2_dlhq_1
XM51 t51 t50 vdd_cpu vss sg13g2_inv_1
XL51 q51 t51 gate vdd_mem vss sg13g2_dlhq_1
XM52 t52 t51 vdd_cpu vss sg13g2_inv_1
XL52 q52 t52 gate vdd_mem vss sg13g2_dlhq_1
XM53 t53 t52 vdd_cpu vss sg13g2_inv_1
XL53 q53 t53 gate vdd_mem vss sg13g2_dlhq_1
XM54 t54 t53 vdd_cpu vss sg13g2_inv_1
XL54 q54 t54 gate vdd_mem vss sg13g2_dlhq_1
XM55 t55 t54 vdd_cpu vss sg13g2_inv_1
XL55 q55 t55 gate vdd_mem vss sg13g2_dlhq_1
XM56 t56 t55 vdd_cpu vss sg13g2_inv_1
XL56 q56 t56 gate vdd_mem vss sg13g2_dlhq_1
XM57 t57 t56 vdd_cpu vss sg13g2_inv_1
XL57 q57 t57 gate vdd_mem vss sg13g2_dlhq_1
XM58 t58 t57 vdd_cpu vss sg13g2_inv_1
XL58 q58 t58 gate vdd_mem vss sg13g2_dlhq_1
XM59 t59 t58 vdd_cpu vss sg13g2_inv_1
XL59 q59 t59 gate vdd_mem vss sg13g2_dlhq_1
XM60 t60 t59 vdd_cpu vss sg13g2_inv_1
XL60 q60 t60 gate vdd_mem vss sg13g2_dlhq_1
XM61 t61 t60 vdd_cpu vss sg13g2_inv_1
XL61 q61 t61 gate vdd_mem vss sg13g2_dlhq_1
XM62 t62 t61 vdd_cpu vss sg13g2_inv_1
XL62 q62 t62 gate vdd_mem vss sg13g2_dlhq_1
XM63 t63 t62 vdd_cpu vss sg13g2_inv_1
XL63 q63 t63 gate vdd_mem vss sg13g2_dlhq_1
XM64 t64 t63 vdd_cpu vss sg13g2_inv_1
XL64 q64 t64 gate vdd_mem vss sg13g2_dlhq_1
.ends droop_detector

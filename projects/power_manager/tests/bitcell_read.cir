* Read current of the IHP SRAM bitcell (RM_IHPSG13_2048x32_c2_1P_BITKIT_CELL in the macro's CDL: access and pull-down NMOS both 0.3/0.13 um in series, the stored node's other side at vdd) with the bit line and word line at vdd, at 1.08, 1.20 and 1.32 V (the supplies IHP characterizes the macro at), written to read.txt; corner and temperature come from corner.inc.
.include corner.inc
VBL bl 0 1.08
VWL wl 0 1.08
VNT nt 0 1.08
XAX bl wl nc 0 sg13_lv_nmos w=0.3u l=0.13u
XPD nc nt 0 0 sg13_lv_nmos w=0.3u l=0.13u
.control
echo "vdd_v read_a" > read.txt
foreach v 1.08 1.2 1.32
  alter VBL dc = $v
  alter VWL dc = $v
  alter VNT dc = $v
  op
  let ir = -i(VBL)
  echo "$v $&ir" >> read.txt
end
quit
.endc
.end

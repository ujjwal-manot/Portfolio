* Supervisor bench: the bandgap (trim code 8) and the supervisor from 0 V: vin ramps to 3.3 V in {ramp} (ramp.inc), vdd_mem follows 20 us later and reaches 1.2 V in 50 us; 150 us after the ramp vin falls to 2.7 V and climbs back to 3.3 V at 1 mV/us, then vdd_mem falls to 1.05 V and climbs back to 1.2 V at 0.3 mV/us; every time point of vin, vdd_mem, vin_ok, mem_ok, rst_n, vref and the supply current is written to sup.txt, so a run that stops early leaves a short file; corner and mismatch from corner.inc.
.include corner.inc
.include ramp.inc
.include bandgap_sizes.inc
.include bandgap.cir
.include supervisor_sizes.inc
.include supervisor.cir
.param t0={ramp + 150u}
VIN vin 0 pwl(0 0 {ramp} 3.3 {t0} 3.3 {t0 + 600u} 2.7 {t0 + 1200u} 3.3)
VMEM vdd_mem 0 pwl(0 0 {ramp + 20u} 0 {ramp + 70u} 1.2 {t0 + 1250u} 1.2 {t0 + 1750u} 1.05 {t0 + 2250u} 1.2)
XBG vref vg vin 0 vin 0 0 0 bandgap
XS rst_n vin_ok mem_ok vin vdd_mem vref vg 0 supervisor
.tran 1u {t0 + 2300u}
.control
run
wrdata sup.txt v(vin) v(vdd_mem) v(vin_ok) v(mem_ok) v(rst_n) v(vref) i(VIN)
.endc
.end

* Sweeps the droop detector (design/droop_detector.cir) over vdd_cpu from 0.800 to 1.250 V in 25 mV steps with vdd_mem at 1.2 V: one rising clk edge per point, and 7 ns later every capture flop's output is written to detector.txt as one line, vdd_cpu then the 80 flop outputs in volts; each point runs on fresh plots, so a failed run leaves no stale numbers; corner and temperature come from corner.inc.
.include corner.inc
.include sg13g2_stdcell.spice
.include droop_detector.cir
VCPU vdd_cpu 0 1.0
VMEM vdd_mem 0 1.2
VCLK clk 0 pulse(0 1.2 1n 50p 50p 10n 20n)
XD clk q1 q2 q3 q4 q5 q6 q7 q8 q9 q10 q11 q12 q13 q14 q15 q16 q17 q18 q19 q20 q21 q22 q23 q24 q25 q26 q27 q28 q29 q30 q31 q32 q33 q34 q35 q36 q37 q38 q39 q40 q41 q42 q43 q44 q45 q46 q47 q48 q49 q50 q51 q52 q53 q54 q55 q56 q57 q58 q59 q60 q61 q62 q63 q64 q65 q66 q67 q68 q69 q70 q71 q72 q73 q74 q75 q76 q77 q78 q79 q80 vdd_cpu vdd_mem 0 droop_detector
.tran 5p 8n
.control
let v = 0.8
while v < 1.2501
  destroy all
  alter VCPU dc = v
  run
  set line = ( $&v )
  let k = 1
  while k < 80.5
    let x = v(q$&k)[length(time) - 1]
    set line = ( $line $&x )
    let k = k + 1
  end
  echo $line >> detector.txt
  let v = v + 0.025
end
.endc
.end

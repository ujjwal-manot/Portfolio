* Window comparator before and after layout: dut.cir holds either the schematic or the Magic extraction under the name comparator; the switching threshold is found by bisection (15 halvings of +-20 mV) once after a -50 mV decision and once after a +50 mV one, every step's input and latched outp written to cmp.txt, then the time from the second clk rising edge to the winning output crossing half supply for +1 mV after a -50 mV decision and for -1 mV after a +50 mV one; nothing is preset, so a failed run or measurement leaves its line short or unreadable; corner, temperature and supply come from corner.inc.
.include corner.inc
.include comparator_sizes.inc
.include dut.cir
.option reltol=1e-5 vntol=1e-8
VDD vdd 0 {vsupply}
VCLK clk 0 pulse(0 {vsupply} 5n 50p 50p 9.95n 20n)
VD d 0 pwl(0 -50m 15n -50m 15.1n 0 40n 0)
EP inp 0 vol='0.6 + v(d)/2'
EN inn 0 vol='0.6 - v(d)/2'
XC inp inn clk outp outn vdd 0 comparator
CLP outp 0 5f
CLN outn 0 5f
.control
echo "cmp" > cmp.txt
let nan = 1e400 - 1e400
let lo = 0
let hi = 0
let mid = 0
foreach first -50e-3 50e-3
  let lo = -20e-3
  let hi = 20e-3
  repeat 15
    let mid = (lo + hi) / 2
    alter @VD[pwl] = [ 0 $first 15e-9 $first 15.1e-9 $&mid 40e-9 $&mid ]
    destroy all
    let op = nan
    tran 10p 40n
    let half = v(vdd)[0] / 2
    meas tran op find v(outp) at=38n
    echo "step $first $&mid $&op" >> cmp.txt
    if op > half
      let hi = mid
    else
      let lo = mid
    end
  end
end
alter @VD[pwl] = [ 0 -50e-3 15e-9 -50e-3 15.1e-9 1e-3 40e-9 1e-3 ]
tran 5p 40n
let half = v(vdd)[0] / 2
meas tran tc when v(clk)=$&half rise=2
meas tran tw when v(outp)=$&half rise=1 td=25n
let t = tw - tc
echo "delay 1e-3 $&t" >> cmp.txt
alter @VD[pwl] = [ 0 50e-3 15e-9 50e-3 15.1e-9 -1e-3 40e-9 -1e-3 ]
tran 5p 40n
let half = v(vdd)[0] / 2
meas tran tc when v(clk)=$&half rise=2
meas tran tw when v(outn)=$&half rise=1 td=25n
let t = tw - tc
echo "delay -1e-3 $&t" >> cmp.txt
quit
.endc
.end

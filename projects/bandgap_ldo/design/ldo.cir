* LDO without an external capacitor making vref (1.2 V) from the 3.3 V supply on IHP SG13G2 thick-oxide devices: an NMOS source follower is the pass device (its own source feedback bootstraps most of its gate capacitance and keeps the output impedance low), driven directly by an NMOS-input error amplifier whose PMOS load lets the gate reach the 2.5 V it needs; a high output simply turns the follower off, so the loop cannot latch; a 110 uA NMOS bleed, a PTAT copy like every bias here so the follower's gm and the light-load pole hold with temperature (a flat resistor bleed was tried, see make bleed_study), keeps the follower's gm up at no load (the light-load output pole is gm/C, and below that bleed no compensation keeps both margin and speed), a capacitor on the gate makes it the dominant pole, RC filters on the reference and on the bias line keep supply ripple out at high frequency, and an on-chip MIM capacitor decouples the output; bias currents are copies of the bandgap's PTAT branch through vg; every device carries mm_ok={mm}, sizes come from ldo_sizes.inc.
.subckt ldo vout fb vref vg vdd vss
XPB nb vg vdd vdd sg13_hv_pmos w={w_mir} l={l_mir} m={m_bias} mm_ok={mm}
XNB nb nb vss vss sg13_hv_nmos w={w_nb} l={l_nb} m=1 mm_ok={mm}
XBL vout nbf vss vss sg13_hv_nmos w={w_nb} l={l_nb} m={m_bleed} mm_ok={mm}
XT t nbf vss vss sg13_hv_nmos w={w_nb} l={l_nb} m={m_amp} mm_ok={mm}
XE1 d vf t vss sg13_hv_nmos w={w_ein} l={l_ein} mm_ok={mm}
XE2 g fb t vss sg13_hv_nmos w={w_ein} l={l_ein} mm_ok={mm}
XE3 d d vdd vdd sg13_hv_pmos w={w_eld} l={l_eld} mm_ok={mm}
XE4 g d vdd vdd sg13_hv_pmos w={w_eld} l={l_eld} mm_ok={mm}
XN vdd g vout vss sg13_hv_nmos w={w_pass} l={l_pass} ng={ng_pass} mm_ok={mm}
XCL vout vss cap_cmim w={w_cl} l={w_cl} m={m_cl} mm_ok={mm}
XCG g vss cap_cmim w={w_cg} l={w_cg} mm_ok={mm}
XRF vref vf vss rhigh w=0.5u l={l_rf} mm_ok={mm}
XCFL vf vss cap_cmim w={w_cfl} l={w_cfl} m={m_cfl} mm_ok={mm}
XRN nb nbf vss rhigh w=0.5u l={l_rn} mm_ok={mm}
XCN nbf vss cap_cmim w={w_cn} l={w_cn} mm_ok={mm}
.ends ldo

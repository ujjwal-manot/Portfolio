* LDO DC testbench with the bandgap at trim code 8: vout with no load and with 2 mA (load regulation), vout at 1 mA with a 3.0 and a 3.6 V supply (line regulation), and the supply current of bandgap and LDO together with no load, written to ldo_dc.txt, every earlier plot is dropped before each operating point, so one that does not solve leaves nan, never a stale or preset number; supply and corner from corner.inc.
.include corner.inc
.include bandgap_sizes.inc
.include bandgap.cir
.include ldo_sizes.inc
.include ldo.cir
.option reltol=1e-5 vntol=1e-8
VDD vdd 0 {vsupply}
X1 vref vg vdd 0 vdd 0 0 0 bandgap
X2 vout vout vref vg vdd 0 ldo
ILOAD vout 0 0
.control
let nan = 1e400 - 1e400
let v0 = nan
let v2 = nan
let iq = nan
let va = nan
let vb = nan
let lo = nan
destroy all
op
let v0 = v(vout)
let iq = -i(VDD)
let lo = v(vdd)
alter iload = 2m
destroy all
op
let v2 = v(vout)
alter iload = 1m
let s1 = lo - 0.3
alter vdd = $&s1
destroy all
op
let va = v(vout)
let s2 = lo + 0.3
alter vdd = $&s2
destroy all
op
let vb = v(vout)
let line = (vb - va) / 0.6
let reg = v0 - v2
echo ldo_dc vout_v $&v0 vout_2ma_v $&v2 load_reg_v $&reg line_v_per_v $&line iq_a $&iq > ldo_dc.txt
quit
.endc
.end

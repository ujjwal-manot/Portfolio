* LDO Monte Carlo at 125 C with the production trim done in the same run, so one mismatch draw covers both: at 27 C vref is solved at trim codes 8 and 9 and the code nearest 1.2063 V is set (as tests/dc.cir trims), then at 125 C the no-load supply current of bandgap and LDO together, the rail's lowest point through a 0 to 0.5 mA load step in 100 ns, and the no-load phase margin by Tian's method (the 0 V source Vi and current source Ii in the feedback wire stay at zero for the other runs) are measured and written to mc.txt with the code; corner, supply, mismatch and seed come from corner.inc.
.include corner.inc
.include bandgap_sizes.inc
.include bandgap.cir
.include ldo_sizes.inc
.include ldo.cir
VDD vdd 0 {vsupply}
VT3 t3 0 {vsupply}
VT2 t2 0 0
VT1 t1 0 0
VT0 t0 0 0
X1 vref vg vdd 0 t3 t2 t1 t0 bandgap
X2 vout x vref vg vdd 0 ldo
Vi vout x dc 0 ac 0
Ii 0 x dc 0 ac 0
VSENSE vout vl 0
ILOAD vl 0 pwl(0 0 20u 0 20.1u 0.5m 40u 0.5m 40.1u 0)
.control
let target = 1.2063
let v8 = 0
let v9 = 0
let hi = 0
let code = 8
let iq = 0
let dip = 0
let pm = 0
let v27 = 0
option reltol=1e-5 vntol=1e-8
option temp=27
op
let v8 = v(vref)
let hi = v(vdd)
alter vt0 = $&hi
op
let v9 = v(vref)
let code = floor(8 + (target - v8) / (v9 - v8) + 0.5)
if code < 0
  let code = 0
end
if code > 15
  let code = 15
end
let b3 = floor(code / 8)
let b2 = floor(code / 4) - 2 * b3
let b1 = floor(code / 2) - 2 * floor(code / 4)
let b0 = code - 2 * floor(code / 2)
let x3 = b3 * hi
let x2 = b2 * hi
let x1 = b1 * hi
let x0 = b0 * hi
alter vt3 = $&x3
alter vt2 = $&x2
alter vt1 = $&x1
alter vt0 = $&x0
op
let v27 = v(vout)
option temp=125
op
let iq = -i(VDD)
tran 1n 40u
meas tran dip_m min v(vout) from=20u to=39u
let dip = dip_m
alter vi acmag = 1
ac dec 50 10 10g
let tv = -v(vout) / v(x)
set first = $curplot
alter vi acmag = 0
alter ii acmag = 1
ac dec 50 10 10g
let ti = -i(vi) / (1 + i(vi))
let t = ({$first}.tv * ti - 1) / ({$first}.tv + ti + 2)
let mag = abs(t)
meas ac fc when mag=1 fall=1
let ph = 180 / pi * cph(t)
meas ac phc find ph at=$&fc
let pm = 180 + phc
echo mc code $&code vout27_v $&v27 iq_a $&iq dip_v $&dip pm_deg $&pm > mc.txt
quit
.endc
.end

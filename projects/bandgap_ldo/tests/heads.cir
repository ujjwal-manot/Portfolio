* Contact heads of the segmented resistors, tt resistors at 27 C: each resistor as the schematic draws it (one device) and as the layout draws it (hv_layout.py splits anything over 40 um into equal series segments, each with its own two contact heads, which bandgap_ldo_checks.py pex counts in the extracted netlist: R2 290 um as 8 of 36.25 um, the LDO filters' rhigh 368 and 184 um as 10 and 5 of 36.8 um, R1 40 um and the trim units unchanged), 1 V across each, resistance from the current, and the change in R2/R1 that sets the bandgap's PTAT gain, to heads.txt (nan if the operating point fails).
.lib cornerRES.lib res_typ
.param mm=0
.temp 27
V1S a1 0 1
XR1S a1 0 0 rppd w=1u l=40u
V2S a2 0 1
XR2S a2 0 0 rppd w=1u l=290u
V2L b2 0 1
XR2L1 b2 c1 0 rppd w=1u l=36.25u
XR2L2 c1 c2 0 rppd w=1u l=36.25u
XR2L3 c2 c3 0 rppd w=1u l=36.25u
XR2L4 c3 c4 0 rppd w=1u l=36.25u
XR2L5 c4 c5 0 rppd w=1u l=36.25u
XR2L6 c5 c6 0 rppd w=1u l=36.25u
XR2L7 c6 c7 0 rppd w=1u l=36.25u
XR2L8 c7 0 0 rppd w=1u l=36.25u
VFS af 0 1
XRFS af 0 0 rhigh w=0.5u l=368u
VFL bf 0 1
XRFL1 bf f1 0 rhigh w=0.5u l=36.8u
XRFL2 f1 f2 0 rhigh w=0.5u l=36.8u
XRFL3 f2 f3 0 rhigh w=0.5u l=36.8u
XRFL4 f3 f4 0 rhigh w=0.5u l=36.8u
XRFL5 f4 f5 0 rhigh w=0.5u l=36.8u
XRFL6 f5 f6 0 rhigh w=0.5u l=36.8u
XRFL7 f6 f7 0 rhigh w=0.5u l=36.8u
XRFL8 f7 f8 0 rhigh w=0.5u l=36.8u
XRFL9 f8 f9 0 rhigh w=0.5u l=36.8u
XRFL10 f9 0 0 rhigh w=0.5u l=36.8u
VNS an 0 1
XRNS an 0 0 rhigh w=0.5u l=184u
VNL bn 0 1
XRNL1 bn n1 0 rhigh w=0.5u l=36.8u
XRNL2 n1 n2 0 rhigh w=0.5u l=36.8u
XRNL3 n2 n3 0 rhigh w=0.5u l=36.8u
XRNL4 n3 n4 0 rhigh w=0.5u l=36.8u
XRNL5 n4 0 0 rhigh w=0.5u l=36.8u
.control
let nan = 1e400 - 1e400
let r1 = nan
let r2s = nan
let r2l = nan
let rfs = nan
let rfl = nan
let rns = nan
let rnl = nan
destroy all
op
let r1 = -1 / i(V1S)
let r2s = -1 / i(V2S)
let r2l = -1 / i(V2L)
let rfs = -1 / i(VFS)
let rfl = -1 / i(VFL)
let rns = -1 / i(VNS)
let rnl = -1 / i(VNL)
let ratio = (r2l / r1) / (r2s / r1) - 1
echo heads r1_ohm $&r1 r2_schematic_ohm $&r2s r2_layout_ohm $&r2l r2_over_r1_change $&ratio rf_schematic_ohm $&rfs rf_layout_ohm $&rfl rn_schematic_ohm $&rns rn_layout_ohm $&rnl > heads.txt
quit
.endc
.end

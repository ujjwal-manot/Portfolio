* Electromigration operating point: bandgap (trim code 8) and LDO at the rated 2 mA load, corner and supply from corner.inc; the drain current of every MOS (the .save lines in probes.inc, made by em_check.py from the design) is printed to em.txt for em_check.py, which holds each against the via and track limits of the layout.
.include corner.inc
.include bandgap_sizes.inc
.include bandgap.cir
.include ldo_sizes.inc
.include ldo.cir
.include probes.inc
VDD vdd 0 {vsupply}
X1 vref vg vdd 0 vdd 0 0 0 bandgap
X2 vout vout vref vg vdd 0 ldo
ILOAD vout 0 2m
.control
op
print all > em.txt
quit
.endc
.end

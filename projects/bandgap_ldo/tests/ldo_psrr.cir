* LDO supply rejection with the bandgap at trim code 8 and a 1 mA load: an AC signal on the 3.3 V supply, the rejection to vout at 1 kHz and 1 MHz, written to psrr.txt (nan if a measurement fails); supply and corner from corner.inc.
.include corner.inc
.include bandgap_sizes.inc
.include bandgap.cir
.include ldo_sizes.inc
.include ldo.cir
VDD vdd 0 dc {vsupply} ac 1
X1 vref vg vdd 0 vdd 0 0 0 bandgap
X2 vout vout vref vg vdd 0 ldo
ILOAD vout 0 1m
.control
let nan = 1e400 - 1e400
let p1k = nan
let p1m = nan
ac dec 20 10 100meg
let psrr = -20 * log10(abs(v(vout)))
meas ac p1k find psrr at=1k
meas ac p1m find psrr at=1meg
echo psrr psrr_1k_db $&p1k psrr_1m_db $&p1m > psrr.txt
quit
.endc
.end

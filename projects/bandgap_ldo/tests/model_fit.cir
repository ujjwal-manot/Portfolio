* Transistor measurements the behavioral models are fitted from, at the corner in corner.inc (tt 3.3 V): the bandgap alone at trim code 8, its vref from -40 to 125 C in 5 C steps (to model_curve.txt, temperature and vref), its supply current at -40, 27 and 125 C (ibg lines), how far vg sits below the supply at 27 C, and the capacitance of the LDO's output MIM at 1 MHz (fit line), to model_fit.txt; every value nan if its analysis does not finish.
.include corner.inc
.include bandgap_sizes.inc
.include bandgap.cir
.include ldo_sizes.inc
VDD vdd 0 {vsupply}
X1 vref vg vdd 0 vdd 0 0 0 bandgap
VC c 0 dc 0 ac 1
XCL c 0 cap_cmim w={w_cl} l={w_cl} m={m_cl}
.control
let nan = 1e400 - 1e400
let vsg = nan
let cout = nan
echo "* model fit data" > model_fit.txt
destroy all
dc temp -40 125 5
let n = nan
let n = length(v(vref))
if n = 34
  wrdata model_curve.txt v(vref)
end
foreach t -40 27 125
  destroy all
  let ibg = nan
  set temp = $t
  op
  let ibg = -i(VDD)
  echo "ibg $t $&ibg" >> model_fit.txt
end
destroy all
set temp = 27
op
let vsg = v(vdd) - v(vg)
destroy all
ac lin 1 1meg 1meg
let cout = abs(i(VC)) / (2 * pi * 1e6)
echo "fit vsg_v $&vsg cout_f $&cout" >> model_fit.txt
quit
.endc
.end

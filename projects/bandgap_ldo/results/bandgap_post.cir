* NGSPICE file created from bandgap_pex.ext - technology: ihp-sg13g2

.subckt bandgap_pex vss vg trim0 trim1 trim2 trim3 vref vdd
X0 m1_66639_71# a_64354_200# m1_66463_71# vss sg13_hv_nmos ad=0.34p pd=2.68u as=0.34p ps=2.68u w=1u l=0.5u
X1 m1_72079_71# trim0 m1_6169_17355# vss sg13_hv_nmos ad=0.59312p pd=7.745u as=1.80342p ps=21.685u w=1u l=0.5u
X2 a_58170_400# vg vdd vdd sg13_hv_pmos ad=2.72p pd=16.68u as=2.72p ps=16.68u w=8u l=8u
X3 a_58170_400# a_58170_400# vss vss sg13_hv_nmos ad=0.68p pd=4.68u as=0.68p ps=4.68u w=2u l=4u
X4 m1_68095_71# m1_68639_71# vss rppd l=2u w=1u
X5 m1_8861_17155# a a_122_1600# vdd sg13_hv_pmos ad=3.4p pd=20.68u as=1.9p ps=10.38u w=10u l=8u
X6 m1_8861_17155# a a_122_1600# vdd sg13_hv_pmos ad=1.9p pd=10.38u as=1.9p ps=10.38u w=10u l=8u
X7 m1_8861_17155# a a_122_1600# vdd sg13_hv_pmos ad=1.9p pd=10.38u as=1.9p ps=10.38u w=10u l=8u
X8 a_122_1600# a m1_8861_17155# vdd sg13_hv_pmos ad=1.9p pd=10.38u as=1.9p ps=10.38u w=10u l=8u
X9 a_122_1600# a m1_8861_17155# vdd sg13_hv_pmos ad=1.9p pd=10.38u as=1.9p ps=10.38u w=10u l=8u
X10 a_122_1600# a m1_8861_17155# vdd sg13_hv_pmos ad=1.9p pd=10.38u as=3.4p ps=20.68u w=10u l=8u
X11 m1_8861_17155# a a_122_1600# vdd sg13_hv_pmos ad=1.9p pd=10.38u as=1.9p ps=10.38u w=10u l=8u
X12 a_122_1600# a m1_8861_17155# vdd sg13_hv_pmos ad=1.9p pd=10.38u as=1.9p ps=10.38u w=10u l=8u
X13 m1_65551_71# trim0 m1_65919_71# vss sg13_hv_nmos ad=0.59312p pd=7.745u as=0.88622p ps=8.375u w=1u l=0.5u
X14 m1_72079_71# a_64354_200# m1_71903_71# vss sg13_hv_nmos ad=0 pd=0 as=0.88622p ps=8.375u w=1u l=0.5u
X15 m1_67551_71# m1_68095_71# vss rppd l=2u w=1u
X16 a_29882_1600# vss cap_cmim l=20u w=20u
X17 m1_8353_17355# a_36760_18584# m1_36693_17155# vdd sg13_hv_pmos ad=17.69473p pd=0.22238m as=14.73932p ps=0.18522m w=10u l=8u
X18 m1_8353_17355# a_36760_18584# m1_36693_17155# vdd sg13_hv_pmos ad=0 pd=0 as=0 ps=0 w=10u l=8u
X19 m1_8353_17355# a_36760_18584# m1_36693_17155# vdd sg13_hv_pmos ad=0 pd=0 as=0 ps=0 w=10u l=8u
X20 m1_36693_17155# a_36760_18584# m1_8353_17355# vdd sg13_hv_pmos ad=0 pd=0 as=0 ps=0 w=10u l=8u
X21 m1_36693_17155# a_36760_18584# m1_8353_17355# vdd sg13_hv_pmos ad=0 pd=0 as=0 ps=0 w=10u l=8u
X22 m1_36693_17155# a_36760_18584# m1_8353_17355# vdd sg13_hv_pmos ad=0 pd=0 as=0 ps=0 w=10u l=8u
X23 m1_8353_17355# a_36760_18584# m1_36693_17155# vdd sg13_hv_pmos ad=0 pd=0 as=0 ps=0 w=10u l=8u
X24 m1_36693_17155# a_36760_18584# m1_8353_17355# vdd sg13_hv_pmos ad=0 pd=0 as=0 ps=0 w=10u l=8u
X25 vg vg vdd vdd sg13_hv_pmos ad=16.63082p pd=0.15145m as=0.27219n ps=1.87098m w=8u l=8u
X26 m1_65551_71# a_64354_200# m1_65375_71# vss sg13_hv_nmos ad=0 pd=0 as=0.88622p ps=8.375u w=1u l=0.5u
X27 m1_70991_71# trim0 m1_71359_71# vss sg13_hv_nmos ad=0.59312p pd=7.745u as=0.88622p ps=8.375u w=1u l=0.5u
X28 m1_67007_71# m1_67551_71# vss rppd l=2u w=1u
X29 m1_64463_71# trim0 m1_64831_71# vss sg13_hv_nmos ad=0.59312p pd=7.745u as=0.88622p ps=8.375u w=1u l=0.5u
X30 m1_70991_71# a_64354_200# m1_70815_71# vss sg13_hv_nmos ad=0 pd=0 as=0.88622p ps=8.375u w=1u l=0.5u
X31 m1_64463_71# a_64354_200# m1_64287_71# vss sg13_hv_nmos ad=0 pd=0 as=0.88622p ps=8.375u w=1u l=0.5u
X32 m1_69903_71# trim0 m1_70271_71# vss sg13_hv_nmos ad=0.59312p pd=7.745u as=0.88622p ps=8.375u w=1u l=0.5u
X33 m1_69903_71# a_64354_200# m1_69727_71# vss sg13_hv_nmos ad=0 pd=0 as=0.88622p ps=8.375u w=1u l=0.5u
X34 m1_66463_71# m1_67007_71# vss rppd l=2u w=1u
X35 m1_65919_71# m1_66463_71# vss rppd l=2u w=1u
X36 m1_65375_71# m1_65919_71# vss rppd l=2u w=1u
X37 m1_64831_71# m1_65375_71# vss rppd l=2u w=1u
X38 m1_64287_71# m1_64831_71# vss rppd l=2u w=1u
X39 e3 m1_83956_7276# vss rppd l=36.25u w=1u
X40 vref trim3 m1_78607_71# vss sg13_hv_nmos ad=0.39542p pd=5.165u as=0.59312p ps=7.745u w=1u l=0.5u
X41 m1_83956_7276# m1_83476_7276# vss rppd l=36.25u w=1u
X42 m1_74461_16605# vss vdd vdd sg13_hv_pmos ad=0.17p pd=1.68u as=0.17p ps=1.68u w=0.5u l=10u
X43 vref a_79586_200# m1_77519_71# vss sg13_hv_nmos ad=0 pd=0 as=0.59312p ps=7.745u w=1u l=0.5u
X44 m1_83476_7276# m1_82996_7276# vss rppd l=36.25u w=1u
X45 m1_78607_71# trim2 m1_76431_71# vss sg13_hv_nmos ad=0 pd=0 as=0.59312p ps=7.745u w=1u l=0.5u
X46 m1_71877_16605# vss m1_74461_16605# vdd sg13_hv_pmos ad=0.23542p pd=3.165u as=0.23542p ps=3.165u w=0.5u l=10u
X47 m1_82996_7276# m1_82516_7276# vss rppd l=36.25u w=1u
X48 a_61534_200# a_58170_400# vss vss sg13_hv_nmos ad=0.38p pd=2.38u as=0.68p ps=4.68u w=2u l=4u
X49 vss a_58170_400# a_61534_200# vss sg13_hv_nmos ad=0.68p pd=4.68u as=0.38p ps=2.38u w=2u l=4u
X50 m1_78607_71# a_77410_200# m1_75343_71# vss sg13_hv_nmos ad=0 pd=0 as=0.59312p ps=7.745u w=1u l=0.5u
X51 m1_69293_16605# vss m1_71877_16605# vdd sg13_hv_pmos ad=0.23542p pd=3.165u as=0 ps=0 w=0.5u l=10u
X52 m1_82516_7276# m1_82036_7276# vss rppd l=36.25u w=1u
X53 m1_77519_71# trim2 m1_74255_71# vss sg13_hv_nmos ad=0 pd=0 as=0.59312p ps=7.745u w=1u l=0.5u
X54 m1_82036_7276# m1_81556_7276# vss rppd l=36.25u w=1u
X55 m1_66709_16605# vss m1_69293_16605# vdd sg13_hv_pmos ad=0.23542p pd=3.165u as=0 ps=0 w=0.5u l=10u
X56 m1_77519_71# a_77410_200# m1_73167_71# vss sg13_hv_nmos ad=0 pd=0 as=0.59312p ps=7.745u w=1u l=0.5u
X57 m1_81556_7276# m1_81076_7276# vss rppd l=36.25u w=1u
X58 a_61534_200# vss m1_66709_16605# vdd sg13_hv_pmos ad=0.73542p pd=8.685u as=0 ps=0 w=0.5u l=10u
X59 m1_22375_451# a_122_1600# m1_18655_451# vss sg13_hv_nmos ad=2.72p pd=16.68u as=1.52p ps=8.38u w=8u l=8u
X60 m1_18655_451# a_122_1600# m1_22375_451# vss sg13_hv_nmos ad=1.52p pd=8.38u as=2.72p ps=16.68u w=8u l=8u
X61 m1_76431_71# trim1 m1_72079_71# vss sg13_hv_nmos ad=0 pd=0 as=0 ps=0 w=1u l=0.5u
X62 m1_81076_7276# m1_64287_71# vss rppd l=36.25u w=1u
X63 m1_43959_451# a_29882_1600# m1_36887_451# vss sg13_hv_nmos ad=2.72p pd=16.68u as=1.52p ps=8.38u w=8u l=8u
X64 m1_43959_451# a_29882_1600# m1_36887_451# vss sg13_hv_nmos ad=1.52p pd=8.38u as=1.52p ps=8.38u w=8u l=8u
X65 m1_36887_451# a_29882_1600# m1_43959_451# vss sg13_hv_nmos ad=1.52p pd=8.38u as=1.52p ps=8.38u w=8u l=8u
X66 m1_36887_451# a_29882_1600# m1_43959_451# vss sg13_hv_nmos ad=1.52p pd=8.38u as=2.72p ps=16.68u w=8u l=8u
X67 m1_18655_451# a_122_1600# m1_14935_451# vss sg13_hv_nmos ad=3.95312p pd=49.745u as=3.95312p ps=49.745u w=8u l=8u
X68 m1_14935_451# a_122_1600# m1_18655_451# vss sg13_hv_nmos ad=0 pd=0 as=0 ps=0 w=8u l=8u
X69 m1_76431_71# a_73058_200# m1_70991_71# vss sg13_hv_nmos ad=0 pd=0 as=0 ps=0 w=1u l=0.5u
X70 m1_36887_451# a_29882_1600# m1_29815_451# vss sg13_hv_nmos ad=6.58852p pd=82.905u as=6.58852p ps=82.905u w=8u l=8u
X71 m1_36887_451# a_29882_1600# m1_29815_451# vss sg13_hv_nmos ad=0 pd=0 as=0 ps=0 w=8u l=8u
X72 m1_29815_451# a_29882_1600# m1_36887_451# vss sg13_hv_nmos ad=0 pd=0 as=0 ps=0 w=8u l=8u
X73 m1_29815_451# a_29882_1600# m1_36887_451# vss sg13_hv_nmos ad=0 pd=0 as=0 ps=0 w=8u l=8u
X74 m1_75343_71# trim1 m1_69903_71# vss sg13_hv_nmos ad=0 pd=0 as=0 ps=0 w=1u l=0.5u
X75 m1_14935_451# a_122_1600# a_29882_1600# vss sg13_hv_nmos ad=0 pd=0 as=42.33412p ps=0.3661m w=8u l=8u
X76 a_29882_1600# a_122_1600# m1_14935_451# vss sg13_hv_nmos ad=0 pd=0 as=0 ps=0 w=8u l=8u
X77 m1_29815_451# a_29882_1600# vg vss sg13_hv_nmos ad=0 pd=0 as=0 ps=0 w=8u l=8u
X78 m1_29815_451# a_29882_1600# vg vss sg13_hv_nmos ad=0 pd=0 as=0 ps=0 w=8u l=8u
X79 vg a_29882_1600# m1_29815_451# vss sg13_hv_nmos ad=0 pd=0 as=0 ps=0 w=8u l=8u
X80 vg a_29882_1600# m1_29815_451# vss sg13_hv_nmos ad=0 pd=0 as=0 ps=0 w=8u l=8u
X81 vss a_122_1600# m1_7495_451# vss sg13_hv_nmos ad=0.30281n pd=1.98864m as=3.95312p ps=49.745u w=8u l=8u
X82 m1_7495_451# a_122_1600# vss vss sg13_hv_nmos ad=0 pd=0 as=0 ps=0 w=8u l=8u
X83 m1_75343_71# a_73058_200# m1_68815_71# vss sg13_hv_nmos ad=0 pd=0 as=0.59312p ps=7.745u w=1u l=0.5u
X84 vss a_29882_1600# m1_43959_451# vss sg13_hv_nmos ad=0 pd=0 as=6.58852p ps=82.905u w=8u l=8u
X85 vss a_29882_1600# m1_43959_451# vss sg13_hv_nmos ad=0 pd=0 as=0 ps=0 w=8u l=8u
X86 m1_43959_451# a_29882_1600# vss vss sg13_hv_nmos ad=0 pd=0 as=0 ps=0 w=8u l=8u
X87 m1_43959_451# a_29882_1600# vss vss sg13_hv_nmos ad=0 pd=0 as=0 ps=0 w=8u l=8u
X88 m1_7495_451# a_122_1600# m1_3775_451# vss sg13_hv_nmos ad=0 pd=0 as=3.95312p ps=49.745u w=8u l=8u
X89 m1_3775_451# a_122_1600# m1_7495_451# vss sg13_hv_nmos ad=0 pd=0 as=0 ps=0 w=8u l=8u
X90 m1_3775_451# a_122_1600# m1_55_451# vss sg13_hv_nmos ad=0 pd=0 as=3.95312p ps=49.745u w=8u l=8u
X91 m1_55_451# a_122_1600# m1_3775_451# vss sg13_hv_nmos ad=0 pd=0 as=0 ps=0 w=8u l=8u
X92 m1_55_451# a_122_1600# a_122_1600# vss sg13_hv_nmos ad=0 pd=0 as=41.93892p ps=0.36514m w=8u l=8u
X93 a_122_1600# a_122_1600# m1_55_451# vss sg13_hv_nmos ad=0 pd=0 as=0 ps=0 w=8u l=8u
X94 vss a_122_1600# m1_22375_451# vss sg13_hv_nmos ad=0 pd=0 as=3.95312p ps=49.745u w=8u l=8u
X95 m1_22375_451# a_122_1600# vss vss sg13_hv_nmos ad=0 pd=0 as=0 ps=0 w=8u l=8u
X96 e8 a_36760_18584# vss rppd l=40u w=1u
X97 m1_71903_71# m1_6169_17355# vss rppd l=2u w=1u
X98 a_79586_200# trim3 vss vss sg13_hv_nmos ad=0.68542p pd=8.685u as=0 ps=0 w=1u l=0.5u
X99 m1_71359_71# m1_71903_71# vss rppd l=2u w=1u
X100 a_77410_200# trim2 vss vss sg13_hv_nmos ad=0.81542p pd=10.205u as=0 ps=0 w=1u l=0.5u
X101 m1_68815_71# trim0 m1_69183_71# vss sg13_hv_nmos ad=0 pd=0 as=0.88622p ps=8.375u w=1u l=0.5u
X102 a_79586_200# trim3 vdd vdd sg13_hv_pmos ad=0.68p pd=4.68u as=0.68p ps=4.68u w=2u l=0.5u
X103 m1_70815_71# m1_71359_71# vss rppd l=2u w=1u
X104 a_77410_200# trim2 vdd vdd sg13_hv_pmos ad=0 pd=0 as=0 ps=0 w=2u l=0.5u
X105 a_73058_200# trim1 vss vss sg13_hv_nmos ad=1.07542p pd=13.245u as=0 ps=0 w=1u l=0.5u
X106 m1_68815_71# a_64354_200# m1_68639_71# vss sg13_hv_nmos ad=0 pd=0 as=0.88622p ps=8.375u w=1u l=0.5u
X107 m1_74255_71# trim1 m1_67727_71# vss sg13_hv_nmos ad=0 pd=0 as=0.59312p ps=7.745u w=1u l=0.5u
X108 m1_70271_71# m1_70815_71# vss rppd l=2u w=1u
X109 m1_6169_17355# vg vdd vdd sg13_hv_pmos ad=0 pd=0 as=0 ps=0 w=8u l=8u
X110 a_64354_200# trim0 vss vss sg13_hv_nmos ad=1.59543p pd=19.325u as=0 ps=0 w=1u l=0.5u
X111 m1_67727_71# trim0 m1_68095_71# vss sg13_hv_nmos ad=0 pd=0 as=0.88622p ps=8.375u w=1u l=0.5u
X112 m1_74255_71# a_73058_200# m1_66639_71# vss sg13_hv_nmos ad=0 pd=0 as=0.59312p ps=7.745u w=1u l=0.5u
X113 a_73058_200# trim1 vdd vdd sg13_hv_pmos ad=0 pd=0 as=0 ps=0 w=2u l=0.5u
X114 vg a_61534_200# vss vss sg13_hv_nmos ad=0.34p pd=2.68u as=0.34p ps=2.68u w=1u l=1u
X115 m1_69727_71# m1_70271_71# vss rppd l=2u w=1u
X116 a_36760_18584# vg vdd vdd sg13_hv_pmos ad=36.26892p pd=0.28678m as=0 ps=0 w=8u l=8u
X117 a_64354_200# trim0 vdd vdd sg13_hv_pmos ad=0 pd=0 as=0 ps=0 w=2u l=0.5u
X118 m1_67727_71# a_64354_200# m1_67551_71# vss sg13_hv_nmos ad=0 pd=0 as=0.88622p ps=8.375u w=1u l=0.5u
X119 m1_73167_71# trim1 m1_65551_71# vss sg13_hv_nmos ad=0 pd=0 as=0 ps=0 w=1u l=0.5u
X120 m1_69183_71# m1_69727_71# vss rppd l=2u w=1u
X121 m1_36693_17155# a_36760_18584# a_29882_1600# vdd sg13_hv_pmos ad=0 pd=0 as=0 ps=0 w=10u l=8u
X122 m1_36693_17155# a_36760_18584# a_29882_1600# vdd sg13_hv_pmos ad=0 pd=0 as=0 ps=0 w=10u l=8u
X123 m1_36693_17155# a_36760_18584# a_29882_1600# vdd sg13_hv_pmos ad=0 pd=0 as=0 ps=0 w=10u l=8u
X124 a_29882_1600# a_36760_18584# m1_36693_17155# vdd sg13_hv_pmos ad=0 pd=0 as=0 ps=0 w=10u l=8u
X125 a_29882_1600# a_36760_18584# m1_36693_17155# vdd sg13_hv_pmos ad=0 pd=0 as=0 ps=0 w=10u l=8u
X126 a_29882_1600# a_36760_18584# m1_36693_17155# vdd sg13_hv_pmos ad=0 pd=0 as=0 ps=0 w=10u l=8u
X127 m1_36693_17155# a_36760_18584# a_29882_1600# vdd sg13_hv_pmos ad=0 pd=0 as=0 ps=0 w=10u l=8u
X128 a_29882_1600# a_36760_18584# m1_36693_17155# vdd sg13_hv_pmos ad=0 pd=0 as=0 ps=0 w=10u l=8u
X129 a vg vdd vdd sg13_hv_pmos ad=37.86252p pd=0.29011m as=0 ps=0 w=8u l=8u
X130 m1_66639_71# trim0 m1_67007_71# vss sg13_hv_nmos ad=0 pd=0 as=0.88622p ps=8.375u w=1u l=0.5u
X131 m1_73167_71# a_73058_200# m1_64463_71# vss sg13_hv_nmos ad=0 pd=0 as=0 ps=0 w=1u l=0.5u
X132 m1_68639_71# m1_69183_71# vss rppd l=2u w=1u
X133 m1_8353_17355# vg vdd vdd sg13_hv_pmos ad=0 pd=0 as=0 ps=0 w=8u l=8u
X134 m1_8353_17355# a m1_8861_17155# vdd sg13_hv_pmos ad=0 pd=0 as=14.73932p ps=0.18522m w=10u l=8u
X135 m1_8353_17355# a m1_8861_17155# vdd sg13_hv_pmos ad=0 pd=0 as=0 ps=0 w=10u l=8u
X136 m1_8353_17355# a m1_8861_17155# vdd sg13_hv_pmos ad=0 pd=0 as=0 ps=0 w=10u l=8u
X137 m1_8861_17155# a m1_8353_17355# vdd sg13_hv_pmos ad=0 pd=0 as=0 ps=0 w=10u l=8u
X138 m1_8861_17155# a m1_8353_17355# vdd sg13_hv_pmos ad=0 pd=0 as=0 ps=0 w=10u l=8u
X139 m1_8861_17155# a m1_8353_17355# vdd sg13_hv_pmos ad=0 pd=0 as=0 ps=0 w=10u l=8u
X140 m1_8353_17355# a m1_8861_17155# vdd sg13_hv_pmos ad=0 pd=0 as=0 ps=0 w=10u l=8u
X141 m1_8861_17155# a m1_8353_17355# vdd sg13_hv_pmos ad=0 pd=0 as=0 ps=0 w=10u l=8u
C0 m1_18655_451# a_29882_1600# 0.38606f
C1 a_64354_200# a_77410_200# 0.06084f
C2 rppd$1_6/a_0_0# m1_64287_71# 0.06637f
C3 m1_76431_71# m1_72079_71# 1.1423f
C4 m1_69183_71# m1_70815_71# 0.01566f
C5 m1_82516_7276# m1_64287_71# 0.06981f
C6 rppd$1_0/a_0_0# rppd$1_1/a_0_0# 0.15396f
C7 m1_69183_71# a_79586_200# 0.01071f
C8 a_122_1600# m1_8861_17155# 0.6585f
C9 vg a_77410_200# 0.14139f
C10 e3 m1_65375_71# 0.12382f
C11 m1_68815_71# m1_65375_71# 0.04485f
C12 trim0 a 0.10102f
C13 m1_82996_7276# m1_64287_71# 0.06491f
C14 m1_73167_71# m1_74255_71# 1.36399f
C15 m1_75343_71# m1_66463_71# 0.04485f
C16 m1_67727_71# m1_69903_71# 0.04184f
C17 trim3 m1_70815_71# 0.01071f
C18 a_73058_200# m1_70815_71# 0.04282f
C19 trim3 a_79586_200# 16.30701f
C20 m1_64831_71# trim0 4.78868f
C21 a_73058_200# a_79586_200# 0.04413f
C22 m1_76431_71# m1_71903_71# 0.04485f
C23 m1_82516_7276# m1_66463_71# 0
C24 m1_76431_71# m1_64287_71# 0.07237f
C25 m1_69727_71# m1_71359_71# 0.01566f
C26 trim2 a_61534_200# 0.04041f
C27 vdd a_77410_200# 0.41511f
C28 trim2 m1_76431_71# 6.29555f
C29 a m1_83476_7276# 0.03798f
C30 m1_82996_7276# m1_66463_71# 0
C31 m1_69727_71# m1_77519_71# 0.04485f
C32 a a_122_1600# 6.8518f
C33 m1_64831_71# m1_83476_7276# 0.03879f
C34 m1_66709_16605# m1_68815_71# 0
C35 m1_67007_71# m1_78607_71# 0.04485f
C36 m1_66639_71# m1_70991_71# 0.04141f
C37 m1_69727_71# m1_82036_7276# 0
C38 m1_65551_71# m1_72079_71# 0.0413f
C39 m1_69727_71# m1_69903_71# 0.12524f
C40 m1_76431_71# m1_66463_71# 0.04485f
C41 m1_70271_71# m1_70991_71# 0.04485f
C42 m1_71877_16605# m1_70991_71# 0
C43 m1_74255_71# a_36760_18584# 0.05314f
C44 m1_67007_71# m1_67551_71# 10.43722f
C45 a_64354_200# m1_65919_71# 0.06497f
C46 trim0 a_77410_200# 0.05633f
C47 e3 m1_70815_71# 0.06878f
C48 m1_6169_17355# m1_55_451# 0.00248f
C49 m1_68639_71# m1_70991_71# 0.04485f
C50 m1_68815_71# m1_70815_71# 0.01497f
C51 m1_67551_71# rppd$2_8/a_0_0# 0.0369f
C52 m1_68815_71# a_79586_200# 0.05835f
C53 m1_64463_71# a_61534_200# 0.05578f
C54 m1_70271_71# vref 0.0316f
C55 m1_82036_7276# m1_81556_7276# 0.79068f
C56 m1_75343_71# a_29882_1600# 0.07645f
C57 m1_65551_71# m1_71903_71# 0.01495f
C58 trim2 m1_65551_71# 0.05835f
C59 vref m1_68639_71# 0.0316f
C60 m1_65551_71# m1_64287_71# 0.07237f
C61 m1_71903_71# m1_72079_71# 0.11973f
C62 a_58170_400# m1_74255_71# 0.0682f
C63 m1_66639_71# m1_68095_71# 0.01501f
C64 trim2 m1_72079_71# 0.05764f
C65 m1_64287_71# m1_72079_71# 0.07237f
C66 m1_70271_71# m1_68095_71# 0.01535f
C67 a_64354_200# vg 0.32415f
C68 m1_74255_71# m1_74461_16605# 0
C69 m1_65551_71# m1_66463_71# 0.63734f
C70 m1_67007_71# m1_67727_71# 0.04485f
C71 m1_74255_71# m1_69183_71# 0.04485f
C72 m1_68095_71# m1_68639_71# 10.42592f
C73 a_29882_1600# a_61534_200# 0.0602f
C74 m1_76431_71# a_29882_1600# 0.07645f
C75 m1_29815_451# a_29882_1600# 5.92994f
C76 e8 m1_71359_71# 0.05075f
C77 trim2 m1_71903_71# 0.02141f
C78 m1_71903_71# m1_64287_71# 0.02412f
C79 m1_66463_71# m1_72079_71# 0.04485f
C80 m1_74255_71# trim3 0.08248f
C81 trim2 m1_64287_71# 0.0398f
C82 m1_64463_71# m1_65551_71# 3.16773f
C83 m1_8353_17355# a_29882_1600# 0.02944f
C84 m1_73167_71# trim1 6.2003f
C85 m1_65919_71# trim0 4.82082f
C86 e8 m1_77519_71# 0
C87 a_64354_200# vdd 0.4149f
C88 a_73058_200# m1_74255_71# 6.15043f
C89 m1_70991_71# m1_65375_71# 0.04485f
C90 vg vdd 47.59317f
C91 rppd$1_2/a_0_0# rppd$1_1/a_0_0# 0.15396f
C92 m1_64463_71# m1_72079_71# 0.86276f
C93 e8 m1_82036_7276# 0.038f
C94 m1_71903_71# m1_66463_71# 0.01501f
C95 m1_65919_71# m1_83476_7276# 0
C96 m1_67007_71# m1_69727_71# 0.0152f
C97 m1_81076_7276# m1_68639_71# 0
C98 vref m1_65375_71# 0.0316f
C99 m1_36693_17155# a_29882_1600# 0.6615f
C100 trim2 m1_66463_71# 0.02141f
C101 m1_66463_71# m1_64287_71# 0.02419f
C102 m1_75343_71# m1_71359_71# 0.04485f
C103 m1_3775_451# m1_55_451# 0.14522f
C104 m1_73167_71# a 0.04485f
C105 m1_83956_7276# m1_68095_71# 0
C106 m1_64463_71# m1_71903_71# 0.01495f
C107 m1_75343_71# m1_77519_71# 0.92881f
C108 a_64354_200# trim0 16.39452f
C109 m1_64831_71# m1_73167_71# 0.06408f
C110 m1_65551_71# a_29882_1600# 0.07729f
C111 m1_66709_16605# m1_70991_71# 0
C112 trim2 m1_64463_71# 0.05835f
C113 m1_67007_71# m1_81556_7276# 0
C114 trim0 vg 0.49341f
C115 a_36760_18584# trim1 0.07616f
C116 m1_64463_71# m1_64287_71# 0.14775f
C117 m1_82996_7276# m1_71359_71# 0
C118 m1_68095_71# m1_65375_71# 0.0152f
C119 m1_74255_71# m1_68815_71# 0.89189f
C120 m1_6169_17355# m1_66639_71# 0.07537f
C121 m1_75343_71# m1_69903_71# 1.1006f
C122 a_29882_1600# m1_72079_71# 0.07687f
C123 m1_82036_7276# m1_82516_7276# 0.81116f
C124 m1_70271_71# m1_6169_17355# 0.05302f
C125 m1_76431_71# m1_71359_71# 0.04485f
C126 m1_70815_71# m1_70991_71# 0.12369f
C127 m1_14935_451# a 0.04453f
C128 trim0 vdd 1.2514f
C129 vg a_122_1600# 0.3406f
C130 a_79586_200# m1_70991_71# 0.05835f
C131 m1_64463_71# m1_66463_71# 0.01497f
C132 m1_6169_17355# m1_68639_71# 0.03557f
C133 m1_82036_7276# m1_82996_7276# 0
C134 m1_76431_71# m1_77519_71# 0.67904f
C135 a_58170_400# trim1 0.11832f
C136 a_36760_18584# a 31.7734f
C137 a_29882_1600# m1_71903_71# 0.00648f
C138 vref m1_70815_71# 0.0316f
C139 trim2 a_29882_1600# 0.0684f
C140 m1_64831_71# a_36760_18584# 0.01774f
C141 rppd$2_10/a_0_0# rppd$2_9/a_0_0# 0.00849f
C142 m1_73167_71# a_77410_200# 6.24843f
C143 vref a_79586_200# 6.32501f
C144 m1_81076_7276# m1_65375_71# 0
C145 vdd m1_69293_16605# 0.56781f
C146 m1_76431_71# m1_69903_71# 0
C147 a_61534_200# m1_69903_71# 0.00172f
C148 rppd_0/a_0_0# a_36760_18584# 0.36668f
C149 vdd a_122_1600# 1.6581f
C150 trim1 m1_69183_71# 0.04282f
C151 m1_82996_7276# rppd$1_1/a_0_0# 0.06637f
C152 a_58170_400# a 0.0627f
C153 m1_68095_71# m1_70815_71# 0.0152f
C154 m1_67007_71# e8 0.05076f
C155 a_29882_1600# m1_66463_71# 0
C156 trim3 trim1 0.04968f
C157 m1_68095_71# a_79586_200# 0.01071f
C158 a_73058_200# trim1 16.28819f
C159 m1_6169_17355# m1_36887_451# 0.07002f
C160 m1_65551_71# m1_71359_71# 0.01495f
C161 m1_6169_17355# m1_83956_7276# 0
C162 a m1_69183_71# 0.05288f
C163 m1_64463_71# a_29882_1600# 0.07729f
C164 a_36760_18584# a_77410_200# 0.04922f
C165 m1_71359_71# m1_72079_71# 0.04485f
C166 m1_6169_17355# m1_65375_71# 0.0257f
C167 m1_64831_71# m1_69183_71# 0.02146f
C168 m1_70271_71# m1_78607_71# 0.04485f
C169 rppd$2_3/a_0_0# rppd$2_4/a_0_0# 0.00849f
C170 m1_77519_71# m1_72079_71# 0
C171 trim3 a 0.02608f
C172 m1_65551_71# m1_69903_71# 0.04141f
C173 m1_73167_71# m1_65919_71# 0.04485f
C174 m1_78607_71# m1_68639_71# 0.04485f
C175 a_73058_200# a 0.05819f
C176 m1_67007_71# m1_75343_71# 0.04485f
C177 m1_67551_71# m1_66639_71# 0.64912f
C178 rppd$2_11/a_0_0# m1_66463_71# 0.05575f
C179 m1_64831_71# trim3 0.01715f
C180 m1_81076_7276# a_79586_200# 0
C181 m1_70271_71# m1_67551_71# 0.0152f
C182 m1_64831_71# a_73058_200# 0.06846f
C183 m1_67007_71# m1_82516_7276# 0
C184 m1_71903_71# m1_71359_71# 10.39092f
C185 m1_72079_71# m1_69903_71# 0.04184f
C186 m1_67551_71# m1_68639_71# 0.67097f
C187 rppd_0/a_0_0# trim3 0.01225f
C188 trim2 m1_71359_71# 0.02141f
C189 a_58170_400# a_77410_200# 0.08115f
C190 m1_71359_71# m1_64287_71# 0.02412f
C191 trim1 m1_68815_71# 0.05896f
C192 m1_77519_71# m1_71903_71# 0.04485f
C193 m1_67007_71# m1_82996_7276# 0
C194 trim2 m1_77519_71# 6.29445f
C195 m1_77519_71# m1_64287_71# 0.07237f
C196 m1_74255_71# m1_70991_71# 0.04154f
C197 a_77410_200# m1_69183_71# 0.02141f
C198 m1_71903_71# m1_69903_71# 0.01497f
C199 a_64354_200# m1_73167_71# 0.05314f
C200 m1_67007_71# m1_76431_71# 0.04485f
C201 trim2 m1_69903_71# 0.05835f
C202 m1_82036_7276# m1_64287_71# 0.07873f
C203 m1_73167_71# vg 0.07496f
C204 m1_71359_71# m1_66463_71# 0.01503f
C205 m1_64287_71# m1_69903_71# 0.07237f
C206 m1_65919_71# a_36760_18584# 0.01773f
C207 e3 a 0.01904f
C208 a m1_68815_71# 0.04485f
C209 m1_67727_71# m1_66639_71# 2.72629f
C210 m1_83956_7276# rppd$2_14/a_0_0# 0.00366f
C211 m1_6169_17355# m1_70815_71# 0.06787f
C212 trim3 a_77410_200# 0.33917f
C213 m1_77519_71# m1_66463_71# 0.04485f
C214 m1_6169_17355# a_79586_200# 0.04401f
C215 a_73058_200# a_77410_200# 0.07644f
C216 m1_64831_71# e3 0.64419f
C217 m1_64831_71# m1_68815_71# 0.06408f
C218 m1_70271_71# m1_67727_71# 0.01495f
C219 m1_64463_71# m1_71359_71# 0.01495f
C220 m1_67727_71# m1_68639_71# 0.66089f
C221 rppd$2_14/a_0_0# m1_65375_71# 0.00366f
C222 rppd$1_0/a_0_0# m1_83956_7276# 0.33711f
C223 m1_82036_7276# m1_66463_71# 0
C224 m1_78607_71# m1_65375_71# 0.04485f
C225 m1_67551_71# m1_83956_7276# 0
C226 m1_66463_71# m1_69903_71# 0.04485f
C227 m1_73167_71# vdd 0.04143f
C228 rppd$1_3/a_0_0# rppd$1_2/a_0_0# 0.15396f
C229 m1_74255_71# m1_68095_71# 0.04485f
C230 rppd$1_1/a_0_0# m1_64287_71# 0
C231 vg m1_14935_451# 0.20103f
C232 m1_67551_71# m1_65375_71# 0.01535f
C233 rppd$1_0/a_0_0# m1_65375_71# 0.00499f
C234 a_64354_200# a_36760_18584# 0.13004f
C235 m1_69727_71# m1_66639_71# 0.01495f
C236 m1_64463_71# m1_69903_71# 0.04134f
C237 vg a_36760_18584# 0.80333f
C238 m1_67007_71# m1_65551_71# 0.01501f
C239 m1_70271_71# m1_69727_71# 10.40852f
C240 m1_65919_71# m1_69183_71# 0.01512f
C241 a_77410_200# m1_68815_71# 0.05835f
C242 rppd$1_4/a_0_0# rppd$1_5/a_0_0# 0.15396f
C243 m1_22375_451# a 0.04453f
C244 m1_69727_71# m1_68639_71# 0.68387f
C245 a_29882_1600# m1_71359_71# 0
C246 m1_73167_71# trim0 0.04485f
C247 m1_67007_71# m1_72079_71# 0.04485f
C248 m1_65919_71# trim3 0.01071f
C249 m1_77519_71# a_29882_1600# 0.07645f
C250 m1_71359_71# rppd$2_3/a_0_0# 0.00366f
C251 a_36760_18584# vdd 0.13721p
C252 a_73058_200# m1_65919_71# 0.04282f
C253 a_58170_400# a_64354_200# 2.15999f
C254 rppd$2_13/a_0_0# rppd$2_12/a_0_0# 0.00849f
C255 a_58170_400# vg 2.26451f
C256 m1_81556_7276# m1_68639_71# 0
C257 m1_78607_71# m1_70815_71# 0.04485f
C258 m1_73167_71# m1_69293_16605# 0
C259 m1_67727_71# m1_65375_71# 0.04485f
C260 a_29882_1600# m1_69903_71# 0.07729f
C261 m1_78607_71# a_79586_200# 0.0503f
C262 m1_67007_71# m1_71903_71# 0.01503f
C263 a_64354_200# m1_69183_71# 0.03285f
C264 trim2 m1_67007_71# 0.02141f
C265 m1_67007_71# m1_64287_71# 0.02416f
C266 vg m1_74461_16605# 0.01278f
C267 m1_66463_71# rppd$2_12/a_0_0# 0.00366f
C268 vg m1_69183_71# 0
C269 m1_67551_71# m1_70815_71# 0.01512f
C270 trim1 m1_70991_71# 0.05896f
C271 m1_67551_71# a_79586_200# 0.01071f
C272 rppd$2_5/a_0_0# rppd$2_6/a_0_0# 0.00849f
C273 a_58170_400# vdd 0.67085f
C274 trim0 a_36760_18584# 0.13004f
C275 m1_69727_71# m1_83956_7276# 0
C276 a_64354_200# trim3 0.05959f
C277 m1_43959_451# m1_36887_451# 1.12594f
C278 rppd$1_3/a_0_0# m1_82516_7276# 0.33711f
C279 vg trim3 0.13468f
C280 a_64354_200# a_73058_200# 0.11128f
C281 vref trim1 0.0316f
C282 a_73058_200# vg 0.18287f
C283 m1_6169_17355# m1_74255_71# 0.0614f
C284 e3 m1_65919_71# 0.09832f
C285 vdd m1_74461_16605# 0.7907f
C286 m1_67007_71# m1_66463_71# 10.44262f
C287 m1_65919_71# m1_68815_71# 0.04485f
C288 rppd$1_3/a_0_0# m1_82996_7276# 0.1061f
C289 m1_14935_451# a_122_1600# 3.17418f
C290 m1_67727_71# m1_66709_16605# 0
C291 m1_69727_71# m1_65375_71# 0.01505f
C292 a m1_70991_71# 0.04485f
C293 a_36760_18584# a_122_1600# 0.24888f
C294 trim3 vdd 1.30309f
C295 m1_64831_71# m1_70991_71# 0.06408f
C296 m1_67007_71# m1_64463_71# 0.01495f
C297 a_58170_400# trim0 0.34148f
C298 m1_70271_71# e8 0.05075f
C299 rppd$2_5/a_0_0# m1_69183_71# 0.0369f
C300 a_73058_200# vdd 0.4149f
C301 m1_68095_71# trim1 0.04282f
C302 vref a 0.03019f
C303 m1_81556_7276# m1_65375_71# 0
C304 m1_77519_71# m1_71359_71# 0.04485f
C305 m1_67727_71# m1_70815_71# 0.01495f
C306 e8 m1_68639_71# 0.05075f
C307 m1_67727_71# a_79586_200# 0.05835f
C308 m1_64831_71# vref 0.04441f
C309 trim0 m1_69183_71# 5.07046f
C310 a_64354_200# m1_68815_71# 6.15645f
C311 m1_71359_71# m1_69903_71# 0.01501f
C312 vg m1_68815_71# 0.07579f
C313 rppd_0/a_0_0# vref 0.09809f
C314 m1_75343_71# m1_66639_71# 0
C315 trim0 trim3 0.04962f
C316 a m1_68095_71# 0.05288f
C317 m1_75343_71# m1_71877_16605# 0
C318 m1_70271_71# m1_75343_71# 0.04485f
C319 a_73058_200# trim0 7.98864f
C320 m1_69293_16605# m1_74461_16605# 0.05984f
C321 m1_83476_7276# m1_69183_71# 0
C322 m1_67007_71# a_29882_1600# 0
C323 m1_64831_71# m1_68095_71# 0.02153f
C324 m1_75343_71# m1_68639_71# 0.04485f
C325 a_77410_200# m1_70991_71# 0.05835f
C326 m1_69727_71# m1_70815_71# 0.69677f
C327 m1_70271_71# m1_82516_7276# 0
C328 m1_69727_71# a_79586_200# 0.01071f
C329 vdd m1_68815_71# 0.02551f
C330 rppd$2_11/a_0_0# rppd$2_12/a_0_0# 0.00849f
C331 m1_82516_7276# m1_68639_71# 0
C332 m1_74255_71# m1_78607_71# 0
C333 m1_70271_71# m1_82996_7276# 0
C334 e8 m1_83956_7276# 0.03793f
C335 vref a_77410_200# 0.0316f
C336 m1_82996_7276# m1_68639_71# 0
C337 rppd$2_7/a_0_0# rppd$2_6/a_0_0# 0.00849f
C338 m1_66639_71# a_61534_200# 0.05578f
C339 m1_67551_71# m1_74255_71# 0.04485f
C340 m1_67007_71# rppd$2_11/a_0_0# 0.00366f
C341 m1_70271_71# m1_76431_71# 0.04485f
C342 e8 m1_65375_71# 0.05077f
C343 m1_81076_7276# a 0.03798f
C344 vg m1_22375_451# 0.87043f
C345 m1_76431_71# m1_71877_16605# 0
C346 m1_64831_71# m1_81076_7276# 0.01309f
C347 m1_76431_71# m1_68639_71# 0.04485f
C348 trim0 m1_68815_71# 6.21107f
C349 a_77410_200# m1_68095_71# 0.02141f
C350 m1_6169_17355# trim1 0.09268f
C351 rppd_0/a_0_0# m1_81076_7276# 0.00583f
C352 rppd$2_7/a_0_0# m1_69183_71# 0.00366f
C353 e3 m1_83476_7276# 0
C354 m1_82516_7276# m1_83956_7276# 0
C355 m1_69293_16605# m1_68815_71# 0
C356 m1_65919_71# m1_70991_71# 0.04485f
C357 m1_75343_71# m1_65375_71# 0.04485f
C358 m1_73167_71# a_36760_18584# 0.05314f
C359 m1_82996_7276# m1_83956_7276# 0
C360 m1_67007_71# m1_71359_71# 0.01505f
C361 rppd$2_1/a_0_0# rppd$2_0/a_0_0# 0.00849f
C362 m1_67727_71# m1_74255_71# 1.05852f
C363 m1_6169_17355# a 0.09645f
C364 m1_82516_7276# m1_65375_71# 0
C365 m1_65551_71# m1_66639_71# 2.94701f
C366 m1_65919_71# vref 0.0316f
C367 m1_67007_71# m1_77519_71# 0.04485f
C368 m1_64831_71# m1_6169_17355# 0.03132f
C369 m1_70271_71# m1_65551_71# 0.01495f
C370 m1_82996_7276# m1_65375_71# 0
C371 m1_71903_71# rppd$2_2/a_0_0# 0.00366f
C372 m1_29815_451# m1_36887_451# 1.12317f
C373 m1_66639_71# m1_72079_71# 0.04134f
C374 e8 m1_70815_71# 0.05075f
C375 m1_65551_71# m1_68639_71# 0.01495f
C376 m1_67007_71# m1_82036_7276# 0
C377 e8 a_79586_200# 0
C378 m1_71877_16605# m1_72079_71# 0
C379 m1_70271_71# m1_72079_71# 0.04485f
C380 m1_67007_71# m1_69903_71# 0.04485f
C381 a_58170_400# m1_73167_71# 0.0682f
C382 a_64354_200# m1_70991_71# 6.13729f
C383 vg m1_70991_71# 0.07579f
C384 m1_76431_71# m1_65375_71# 0.04485f
C385 m1_72079_71# m1_68639_71# 0.04485f
C386 a_36760_18584# m1_14935_451# 0.05834f
C387 m1_65919_71# m1_68095_71# 0.01535f
C388 m1_81076_7276# rppd$1_5/a_0_0# 0.06637f
C389 m1_69727_71# m1_74255_71# 0.04485f
C390 m1_66639_71# m1_71903_71# 0.01495f
C391 m1_73167_71# m1_74461_16605# 0
C392 a_64354_200# vref 0.03713f
C393 m1_73167_71# m1_69183_71# 0.04485f
C394 trim2 m1_66639_71# 0.05835f
C395 m1_22375_451# a_122_1600# 3.14535f
C396 m1_66639_71# m1_64287_71# 0.07237f
C397 m1_70271_71# m1_71903_71# 0.01566f
C398 m1_78607_71# trim1 0.04485f
C399 vg vref 0.09645f
C400 m1_75343_71# m1_70815_71# 0.04485f
C401 m1_70271_71# m1_64287_71# 0.02412f
C402 m1_70271_71# trim2 0.02141f
C403 m1_75343_71# a_79586_200# 0.0514f
C404 m1_6169_17355# a_77410_200# 0.06023f
C405 vdd m1_70991_71# 0.03147f
C406 m1_71903_71# m1_68639_71# 0.01512f
C407 trim2 m1_68639_71# 0.02141f
C408 m1_73167_71# trim3 0.08045f
C409 m1_64287_71# m1_68639_71# 0.02415f
C410 m1_82516_7276# m1_70815_71# 0
C411 m1_67551_71# trim1 0.04282f
C412 a_73058_200# m1_73167_71# 6.15045f
C413 a_64354_200# m1_68095_71# 0.04356f
C414 m1_66709_16605# a_61534_200# 0.03707f
C415 m1_65919_71# m1_81076_7276# 0
C416 a_58170_400# a_36760_18584# 0.08342f
C417 m1_82996_7276# m1_70815_71# 0
C418 vref vdd 0.25395f
C419 m1_66639_71# m1_66463_71# 0.12634f
C420 m1_78607_71# a 0.04485f
C421 m1_70271_71# m1_66463_71# 0.01508f
C422 m1_64831_71# rppd$2_14/a_0_0# 0.05575f
C423 m1_65551_71# m1_65375_71# 0.12648f
C424 m1_64831_71# m1_78607_71# 0.06408f
C425 m1_66463_71# m1_68639_71# 0.01535f
C426 m1_3775_451# a 0.06735f
C427 m1_76431_71# m1_70815_71# 0.04485f
C428 m1_64463_71# m1_66639_71# 0.04184f
C429 a_36760_18584# m1_69183_71# 0.01771f
C430 rppd$2_9/a_0_0# m1_68095_71# 0.00366f
C431 trim0 m1_70991_71# 6.19254f
C432 a_61534_200# a_79586_200# 0.04041f
C433 m1_67551_71# a 0.05288f
C434 m1_76431_71# a_79586_200# 0.0514f
C435 m1_72079_71# m1_65375_71# 0.04485f
C436 rppd_0/a_0_0# m1_78607_71# 0.00853f
C437 m1_70271_71# rppd$2_4/a_0_0# 0.05575f
C438 m1_70271_71# m1_64463_71# 0.01495f
C439 m1_64831_71# m1_67551_71# 0.02161f
C440 m1_64831_71# rppd$1_0/a_0_0# 0.07605f
C441 m1_83956_7276# m1_71903_71# 0
C442 m1_64463_71# m1_68639_71# 0.01495f
C443 rppd$2_6/a_0_0# m1_69183_71# 0.05575f
C444 trim0 vref 0.0316f
C445 trim3 a_36760_18584# 0.03812f
C446 a_73058_200# a_36760_18584# 0.07616f
C447 m1_73167_71# m1_68815_71# 0.04141f
C448 m1_83956_7276# m1_64287_71# 0.06077f
C449 m1_67727_71# trim1 6.20833f
C450 m1_69293_16605# m1_70991_71# 0
C451 rppd$2_3/a_0_0# rppd$2_2/a_0_0# 0.00849f
C452 m1_6169_17355# m1_65919_71# 0.02663f
C453 m1_71903_71# m1_65375_71# 0.01499f
C454 trim2 m1_65375_71# 0.02141f
C455 m1_64287_71# m1_65375_71# 0.58869f
C456 m1_66639_71# a_29882_1600# 0.07729f
C457 m1_78607_71# a_77410_200# 6.24407f
C458 trim0 m1_68095_71# 4.98739f
C459 rppd$2_13/a_0_0# m1_65375_71# 0.05575f
C460 m1_83956_7276# m1_66463_71# 0
C461 a_58170_400# trim3 0.06849f
C462 m1_70271_71# a_29882_1600# 0
C463 m1_67727_71# a 0.04485f
C464 a_58170_400# a_73058_200# 0.11812f
C465 m1_65551_71# m1_70815_71# 0.01495f
C466 m1_65551_71# a_79586_200# 0.05835f
C467 m1_67551_71# a_77410_200# 0.02141f
C468 a_29882_1600# m1_68639_71# 0
C469 m1_69727_71# trim1 0.04282f
C470 m1_64831_71# m1_67727_71# 0.06408f
C471 m1_70271_71# rppd$2_3/a_0_0# 0.0369f
C472 m1_83476_7276# m1_68095_71# 0
C473 m1_66463_71# m1_65375_71# 0.64516f
C474 a_36760_18584# m1_68815_71# 0.05314f
C475 trim3 m1_69183_71# 0.01071f
C476 m1_72079_71# m1_70815_71# 0.04485f
C477 a_64354_200# m1_6169_17355# 0.23793f
C478 a_73058_200# m1_69183_71# 0.04282f
C479 m1_72079_71# a_79586_200# 0.05764f
C480 m1_6169_17355# vg 0.74364f
C481 m1_74255_71# m1_75343_71# 1.13568f
C482 rppd$1_3/a_0_0# m1_82036_7276# 0.06637f
C483 m1_64463_71# m1_65375_71# 0.62557f
C484 a_73058_200# trim3 0.04942f
C485 m1_69727_71# a 0.05288f
C486 m1_71903_71# m1_70815_71# 0.70968f
C487 a m1_43959_451# 0.04518f
C488 m1_71359_71# rppd$2_2/a_0_0# 0.05575f
C489 m1_71903_71# a_79586_200# 0.01071f
C490 m1_6169_17355# vdd 0.67173f
C491 m1_64831_71# m1_69727_71# 0.02144f
C492 trim2 m1_70815_71# 0.02141f
C493 m1_64287_71# m1_70815_71# 0.02412f
C494 a_58170_400# m1_68815_71# 0.06772f
C495 trim2 a_79586_200# 8.06367f
C496 m1_64287_71# a_79586_200# 0.57158f
C497 m1_65919_71# m1_78607_71# 0.04485f
C498 m1_67727_71# a_77410_200# 0.05835f
C499 a_29882_1600# m1_36887_451# 5.96352f
C500 m1_74255_71# m1_76431_71# 0.04184f
C501 m1_81556_7276# a 0.03798f
C502 e3 m1_69183_71# 0.07175f
C503 m1_69183_71# m1_68815_71# 0.76242f
C504 m1_65919_71# m1_67551_71# 0.01566f
C505 m1_65919_71# rppd$1_0/a_0_0# 0.00183f
C506 m1_64831_71# m1_81556_7276# 0.0151f
C507 m1_22375_451# a_36760_18584# 0.05834f
C508 m1_66639_71# m1_71359_71# 0.01495f
C509 rppd_0/a_0_0# rppd$1_7/a_0_0# 0.15396f
C510 m1_66463_71# m1_70815_71# 0.01505f
C511 m1_66463_71# a_79586_200# 0.01071f
C512 m1_70271_71# m1_71359_71# 0.70323f
C513 rppd$2_7/a_0_0# m1_68095_71# 0.0369f
C514 rppd_0/a_0_0# m1_81556_7276# 0
C515 m1_6169_17355# trim0 5.53449f
C516 m1_18655_451# a 0.10516f
C517 trim3 m1_68815_71# 0.09315f
C518 m1_71359_71# m1_68639_71# 0.0152f
C519 m1_70271_71# m1_77519_71# 0.04485f
C520 a_73058_200# m1_68815_71# 6.16125f
C521 rppd$2_4/a_0_0# m1_70815_71# 0.00366f
C522 m1_69727_71# a_77410_200# 0.02141f
C523 a_64354_200# m1_78607_71# 0.05314f
C524 m1_64463_71# m1_70815_71# 0.01495f
C525 m1_64463_71# a_79586_200# 0.08114f
C526 m1_66639_71# m1_69903_71# 0.04154f
C527 m1_77519_71# m1_68639_71# 0.04485f
C528 m1_73167_71# m1_70991_71# 0.04184f
C529 vg m1_78607_71# 0.09414f
C530 m1_70271_71# m1_82036_7276# 0
C531 m1_71877_16605# m1_69903_71# 0
C532 m1_70271_71# m1_69903_71# 0.77336f
C533 m1_82036_7276# m1_68639_71# 0
C534 m1_6169_17355# a_122_1600# 8.79937f
C535 a_64354_200# m1_67551_71# 4.94043f
C536 m1_3775_451# vg 0.0933f
C537 m1_69903_71# m1_68639_71# 0.04485f
C538 m1_74255_71# m1_65551_71# 0
C539 m1_67727_71# m1_65919_71# 0.04485f
C540 m1_78607_71# vdd 0.17518f
C541 m1_74255_71# m1_72079_71# 0.04184f
C542 e8 a 2.89497f
C543 m1_67551_71# rppd$2_9/a_0_0# 0.05575f
C544 m1_83956_7276# m1_71359_71# 0
C545 a_29882_1600# m1_70815_71# 0
C546 m1_75343_71# trim1 6.19972f
C547 a_29882_1600# a_79586_200# 0.05802f
C548 m1_64831_71# e8 0.04437f
C549 m1_73167_71# m1_68095_71# 0.04485f
C550 rppd$1_5/a_0_0# m1_81556_7276# 0.33711f
C551 a_36760_18584# m1_70991_71# 0.05314f
C552 rppd$2_3/a_0_0# m1_70815_71# 0.05575f
C553 e8 rppd_0/a_0_0# 0.03973f
C554 m1_71359_71# m1_65375_71# 0.015f
C555 m1_74255_71# m1_71903_71# 0.04485f
C556 m1_69727_71# m1_65919_71# 0.01508f
C557 trim0 m1_78607_71# 0.04485f
C558 a_64354_200# m1_67727_71# 6.1615f
C559 trim2 m1_74255_71# 6.29553f
C560 m1_74255_71# m1_64287_71# 0.07237f
C561 m1_82036_7276# m1_83956_7276# 0
C562 vref a_36760_18584# 0.48264f
C563 m1_67727_71# vg 0.07638f
C564 m1_77519_71# m1_65375_71# 0.04485f
C565 m1_75343_71# a 0.04485f
C566 m1_67551_71# trim0 0.05427f
C567 a_61534_200# trim1 0.04041f
C568 m1_82036_7276# m1_65375_71# 0
C569 m1_64831_71# m1_75343_71# 0.06408f
C570 m1_76431_71# trim1 6.1997f
C571 a_58170_400# m1_70991_71# 0.06904f
C572 m1_82516_7276# a 0.03798f
C573 m1_65919_71# m1_81556_7276# 0
C574 m1_69903_71# m1_65375_71# 0.04485f
C575 m1_8353_17355# m1_8861_17155# 7.25769f
C576 m1_74255_71# m1_66463_71# 0.04485f
C577 m1_64831_71# m1_82516_7276# 0.02175f
C578 m1_67727_71# vdd 0.0233f
C579 a_36760_18584# m1_68095_71# 0.01771f
C580 m1_82996_7276# a 0.03798f
C581 m1_67007_71# m1_66639_71# 0.73953f
C582 m1_74461_16605# m1_70991_71# 0
C583 a_58170_400# vref 0.0492f
C584 m1_67551_71# m1_83476_7276# 0
C585 m1_64831_71# m1_82996_7276# 0.02789f
C586 m1_69183_71# m1_70991_71# 0.04485f
C587 rppd$1_0/a_0_0# m1_83476_7276# 0.06637f
C588 m1_3775_451# a_122_1600# 3.49396f
C589 m1_83956_7276# rppd$1_1/a_0_0# 0.1061f
C590 a_64354_200# m1_69727_71# 5.10652f
C591 m1_70271_71# m1_67007_71# 0.01512f
C592 rppd$2_10/a_0_0# m1_67551_71# 0.00366f
C593 m1_69727_71# vg 0
C594 vg m1_43959_451# 0.73574f
C595 m1_64463_71# m1_74255_71# 0
C596 m1_67007_71# m1_68639_71# 0.01566f
C597 m1_29815_451# a 0.04518f
C598 m1_76431_71# a 0.04485f
C599 a a_61534_200# 0.03908f
C600 trim3 m1_70991_71# 0.08485f
C601 vref m1_69183_71# 0.0316f
C602 rppd$2_8/a_0_0# m1_68639_71# 0.00366f
C603 m1_71359_71# m1_70815_71# 10.39682f
C604 m1_64831_71# m1_76431_71# 0.06408f
C605 a_73058_200# m1_70991_71# 6.16125f
C606 m1_71359_71# a_79586_200# 0.01071f
C607 m1_66709_16605# m1_69903_71# 0
C608 m1_8353_17355# a 7.60223f
C609 m1_75343_71# a_77410_200# 6.24845f
C610 m1_77519_71# m1_70815_71# 0.04485f
C611 m1_67727_71# trim0 6.22036f
C612 m1_7495_451# a 0.05158f
C613 rppd_0/a_0_0# m1_76431_71# 0.00126f
C614 m1_77519_71# a_79586_200# 6.34263f
C615 rppd$2_1/a_0_0# m1_6169_17355# 0.00366f
C616 trim3 vref 6.39148f
C617 m1_73167_71# m1_6169_17355# 0.0614f
C618 m1_81076_7276# a_36760_18584# 0.0014f
C619 m1_65551_71# trim1 6.20828f
C620 a_73058_200# vref 0.0316f
C621 m1_68095_71# m1_69183_71# 0.67742f
C622 m1_69903_71# m1_70815_71# 0.68444f
C623 m1_69903_71# a_79586_200# 0.05835f
C624 m1_72079_71# trim1 6.20764f
C625 vg m1_18655_451# 0.32687f
C626 m1_69727_71# rppd$2_5/a_0_0# 0.05575f
C627 m1_74255_71# a_29882_1600# 0.07645f
C628 e8 m1_65919_71# 0.05077f
C629 rppd$2_12/a_0_0# m1_65375_71# 0.0369f
C630 trim3 m1_68095_71# 0.01071f
C631 rppd$1_6/a_0_0# rppd$1_5/a_0_0# 0.15396f
C632 m1_67007_71# m1_83956_7276# 0
C633 a_73058_200# m1_68095_71# 0.04282f
C634 m1_76431_71# a_77410_200# 0.05032f
C635 m1_69727_71# trim0 0.03285f
C636 a_77410_200# a_61534_200# 0.04041f
C637 m1_65551_71# a 0.04485f
C638 m1_68815_71# m1_70991_71# 0.04184f
C639 m1_6169_17355# m1_14935_451# 0.05834f
C640 m1_71903_71# trim1 0.04282f
C641 m1_64831_71# m1_65551_71# 0.06408f
C642 trim2 trim1 0.10866f
C643 a m1_72079_71# 0.04485f
C644 m1_67007_71# m1_65375_71# 0.01566f
C645 m1_64287_71# trim1 0.07954f
C646 m1_6169_17355# a_36760_18584# 0.0896f
C647 m1_81076_7276# m1_69183_71# 0
C648 m1_64831_71# m1_72079_71# 0.06408f
C649 m1_69727_71# m1_83476_7276# 0
C650 m1_65919_71# m1_75343_71# 0.04485f
C651 m1_6169_17355# rppd$2_0/a_0_0# 0.05575f
C652 m1_65919_71# m1_82516_7276# 0
C653 trim3 m1_81076_7276# 0
C654 m1_71903_71# a 0.05462f
C655 m1_66463_71# trim1 0.04282f
C656 a m1_64287_71# 0.06069f
C657 m1_65919_71# m1_82996_7276# 0
C658 e3 m1_68095_71# 0.07523f
C659 trim2 a 0.03678f
C660 m1_81556_7276# m1_83476_7276# 0
C661 m1_73167_71# m1_78607_71# 0
C662 m1_64831_71# m1_71903_71# 0.0214f
C663 m1_68095_71# m1_68815_71# 0.04485f
C664 a_58170_400# m1_6169_17355# 0.10001f
C665 trim2 m1_64831_71# 0.03425f
C666 m1_65551_71# a_77410_200# 0.05835f
C667 m1_64831_71# m1_64287_71# 2.36109f
C668 m1_64463_71# trim1 0.05835f
C669 m1_64831_71# rppd$2_13/a_0_0# 0.0369f
C670 trim2 rppd_0/a_0_0# 0.00173f
C671 m1_65919_71# m1_76431_71# 0.04485f
C672 m1_73167_71# m1_67551_71# 0.04485f
C673 a_64354_200# m1_75343_71# 0.05314f
C674 rppd_0/a_0_0# m1_64287_71# 0.07391f
C675 m1_74255_71# m1_71359_71# 0.04485f
C676 m1_6169_17355# m1_69183_71# 0.03929f
C677 a_77410_200# m1_72079_71# 0.05764f
C678 vg m1_75343_71# 0.07496f
C679 a m1_66463_71# 0.05288f
C680 m1_18655_451# a_122_1600# 3.17245f
C681 m1_67007_71# m1_70815_71# 0.01508f
C682 m1_74255_71# m1_77519_71# 1.15445f
C683 rppd$1_2/a_0_0# m1_83476_7276# 0.1061f
C684 m1_67007_71# a_79586_200# 0.01071f
C685 m1_64831_71# m1_66463_71# 0.02207f
C686 m1_6169_17355# trim3 0.04401f
C687 a_73058_200# m1_6169_17355# 0.09268f
C688 m1_64463_71# a 0.04485f
C689 m1_74255_71# m1_69903_71# 0.04141f
C690 a_77410_200# m1_71903_71# 0.02141f
C691 m1_78607_71# a_36760_18584# 0.05369f
C692 m1_75343_71# vdd 0.06164f
C693 trim2 a_77410_200# 16.28417f
C694 m1_64831_71# m1_64463_71# 0.72908f
C695 a_77410_200# m1_64287_71# 0.03981f
C696 a_29882_1600# trim1 0.11089f
C697 a_64354_200# a_61534_200# 2.82517f
C698 a_64354_200# m1_76431_71# 0.05314f
C699 m1_3775_451# a_36760_18584# 0.05834f
C700 m1_76431_71# vg 0.0769f
C701 m1_29815_451# vg 3.99148f
C702 m1_67551_71# a_36760_18584# 0.01773f
C703 vg a_61534_200# 2.68501f
C704 m1_67727_71# m1_73167_71# 0.04134f
C705 e8 m1_83476_7276# 0.03793f
C706 m1_65919_71# m1_65551_71# 0.72792f
C707 vg m1_8353_17355# 0.49212f
C708 a_77410_200# m1_66463_71# 0.02141f
C709 m1_7495_451# vg 0.11348f
C710 a_58170_400# m1_78607_71# 0.06822f
C711 trim0 m1_75343_71# 0.04485f
C712 m1_65919_71# m1_72079_71# 0.04485f
C713 a_29882_1600# a 0.14448f
C714 e3 m1_6169_17355# 0.02942f
C715 m1_76431_71# vdd 0.07876f
C716 m1_6169_17355# m1_68815_71# 0.07418f
C717 vdd a_61534_200# 0.17665f
C718 m1_78607_71# m1_74461_16605# 0
C719 m1_64463_71# a_77410_200# 0.05835f
C720 m1_78607_71# m1_69183_71# 0.04485f
C721 m1_8353_17355# vdd 25.97153f
C722 m1_73167_71# m1_69727_71# 0.04485f
C723 m1_70271_71# m1_66639_71# 0.01495f
C724 m1_65919_71# m1_71903_71# 0.015f
C725 a_64354_200# m1_65551_71# 6.1801f
C726 m1_67727_71# a_36760_18584# 0.05314f
C727 m1_66639_71# m1_68639_71# 0.01497f
C728 trim2 m1_65919_71# 0.02141f
C729 m1_67551_71# m1_69183_71# 0.01566f
C730 m1_82516_7276# m1_83476_7276# 0
C731 trim3 m1_78607_71# 6.41987f
C732 vg m1_65551_71# 0.15044f
C733 m1_65919_71# m1_64287_71# 0.02425f
C734 a_73058_200# m1_78607_71# 0.04485f
C735 m1_36693_17155# vdd 4.60467f
C736 m1_70271_71# m1_68639_71# 0.01566f
C737 trim0 m1_76431_71# 0.04485f
C738 trim0 a_61534_200# 0.14507f
C739 m1_65919_71# rppd$2_13/a_0_0# 0.00366f
C740 m1_82996_7276# m1_83476_7276# 0.85211f
C741 a_64354_200# m1_72079_71# 6.06439f
C742 vg m1_72079_71# 0.07537f
C743 m1_68095_71# m1_70991_71# 0.04485f
C744 m1_67551_71# trim3 0.01071f
C745 m1_71359_71# trim1 0.04282f
C746 a_73058_200# m1_67551_71# 0.04282f
C747 a_77410_200# a_29882_1600# 0.08086f
C748 m1_65551_71# vdd 0.01987f
C749 m1_67007_71# m1_74255_71# 0.04485f
C750 m1_65919_71# m1_66463_71# 10.44772f
C751 m1_6169_17355# m1_22375_451# 0.06386f
C752 m1_77519_71# trim1 0.04485f
C753 a_58170_400# m1_67727_71# 0.06351f
C754 vref m1_68095_71# 0.0316f
C755 m1_69293_16605# a_61534_200# 0.07109f
C756 a_64354_200# m1_71903_71# 5.26802f
C757 m1_69727_71# a_36760_18584# 0.01771f
C758 a_36760_18584# m1_43959_451# 0.09382f
C759 trim2 a_64354_200# 0.06031f
C760 vdd m1_72079_71# 0.03563f
C761 vg m1_71903_71# 0
C762 a_64354_200# m1_64287_71# 4.38061f
C763 m1_64463_71# m1_65919_71# 0.01501f
C764 trim2 vg 0.14224f
C765 m1_8353_17355# a_122_1600# 0.02709f
C766 trim1 m1_69903_71# 6.20835f
C767 a m1_71359_71# 0.05288f
C768 m1_67727_71# m1_69183_71# 0.01501f
C769 m1_69727_71# rppd$2_6/a_0_0# 0.00366f
C770 rppd$1_7/a_0_0# a_36760_18584# 0.06637f
C771 m1_7495_451# a_122_1600# 3.37136f
C772 m1_70271_71# m1_83956_7276# 0
C773 m1_64831_71# m1_71359_71# 0.0214f
C774 m1_77519_71# a 0.04485f
C775 a_36760_18584# m1_81556_7276# 0
C776 trim0 m1_65551_71# 6.23902f
C777 m1_67727_71# trim3 0.10079f
C778 e3 m1_67551_71# 0.0779f
C779 e3 rppd$1_0/a_0_0# 0.03973f
C780 m1_67551_71# m1_68815_71# 0.04485f
C781 m1_66639_71# m1_65375_71# 0.04485f
C782 m1_83956_7276# m1_68639_71# 0
C783 a_64354_200# m1_66463_71# 4.85714f
C784 a_73058_200# m1_67727_71# 0.05678f
C785 m1_64831_71# m1_77519_71# 0.06408f
C786 m1_18655_451# m1_14935_451# 0.14522f
C787 m1_81076_7276# vref 0.00225f
C788 trim2 vdd 1.2539f
C789 m1_70271_71# m1_65375_71# 0.01503f
C790 m1_82036_7276# a 0.03798f
C791 trim0 m1_72079_71# 6.18257f
C792 a m1_69903_71# 0.04485f
C793 m1_18655_451# a_36760_18584# 0.05834f
C794 rppd_0/a_0_0# m1_77519_71# 0.00302f
C795 m1_64831_71# m1_82036_7276# 0.01782f
C796 m1_68639_71# m1_65375_71# 0.01512f
C797 m1_64831_71# m1_69903_71# 0.06408f
C798 a_64354_200# m1_64463_71# 6.18945f
C799 m1_69727_71# m1_69183_71# 10.41432f
C800 m1_64463_71# vg 0.14451f
C801 rppd_0/a_0_0# m1_82036_7276# 0
C802 m1_69293_16605# m1_72079_71# 0
C803 m1_81076_7276# m1_68095_71# 0
C804 trim0 m1_71903_71# 0.01144f
C805 m1_6169_17355# m1_70991_71# 0.06921f
C806 rppd$2_2/a_0_0# m1_70815_71# 0.0369f
C807 trim2 trim0 0.05531f
C808 m1_69727_71# trim3 0.01071f
C809 a_77410_200# m1_71359_71# 0.02141f
C810 trim0 m1_64287_71# 0.15904f
C811 a_73058_200# m1_69727_71# 0.04282f
C812 m1_81556_7276# m1_69183_71# 0
C813 m1_71877_16605# m1_66709_16605# 0.06546f
C814 a_77410_200# m1_77519_71# 6.24462f
C815 m1_73167_71# m1_75343_71# 0.04184f
C816 m1_67727_71# m1_68815_71# 2.50557f
C817 m1_64463_71# vdd 0.01852f
C818 rppd$1_7/a_0_0# trim3 0
C819 m1_6169_17355# vref 0.04263f
C820 m1_71903_71# m1_83476_7276# 0
C821 rppd$2_11/a_0_0# m1_65919_71# 0.0369f
C822 a_64354_200# a_29882_1600# 0.25082f
C823 trim3 m1_81556_7276# 0
C824 e8 a_36760_18584# 0.2038f
C825 m1_83476_7276# m1_64287_71# 0.06181f
C826 m1_66639_71# m1_70815_71# 0.01495f
C827 a_77410_200# m1_69903_71# 0.05835f
C828 m1_66639_71# a_79586_200# 0.05835f
C829 trim0 m1_66463_71# 0.06497f
C830 m1_83956_7276# m1_65375_71# 0
C831 vg a_29882_1600# 6.48249f
C832 rppd$2_5/a_0_0# rppd$2_4/a_0_0# 0.00849f
C833 m1_70271_71# m1_70815_71# 10.40262f
C834 m1_67007_71# trim1 0.04282f
C835 m1_70271_71# a_79586_200# 0.01071f
C836 m1_68639_71# m1_70815_71# 0.01535f
C837 m1_6169_17355# m1_68095_71# 0.03284f
C838 m1_68639_71# a_79586_200# 0.01071f
C839 m1_64463_71# trim0 6.24896f
C840 e3 m1_69727_71# 0.07056f
C841 rppd$1_4/a_0_0# m1_81556_7276# 0.06637f
C842 m1_82036_7276# rppd$1_5/a_0_0# 0.1061f
C843 m1_66463_71# m1_83476_7276# 0
C844 m1_69727_71# m1_68815_71# 0.67267f
C845 m1_73167_71# m1_76431_71# 0.91653f
C846 rppd$2_10/a_0_0# m1_66463_71# 0.0369f
C847 vdd a_29882_1600# 1.65809f
C848 m1_75343_71# a_36760_18584# 0.05314f
C849 m1_65919_71# m1_71359_71# 0.01501f
C850 m1_67007_71# a 0.05288f
C851 m1_65919_71# m1_77519_71# 0.04485f
C852 e8 m1_69183_71# 0.05075f
C853 m1_67007_71# m1_64831_71# 0.02176f
C854 m1_82036_7276# m1_65919_71# 0
C855 m1_83956_7276# m1_70815_71# 0
C856 m1_65919_71# m1_69903_71# 0.04485f
C857 trim0 a_29882_1600# 0.23316f
C858 e8 trim3 0
C859 a_58170_400# m1_75343_71# 0.0682f
C860 m1_67551_71# m1_70991_71# 0.04485f
C861 m1_78607_71# vref 1.38846f
C862 m1_29815_451# a_36760_18584# 0.09025f
C863 m1_76431_71# a_36760_18584# 0.05314f
C864 a_36760_18584# a_61534_200# 0.05289f
C865 a_64354_200# m1_71359_71# 0.01144f
C866 m1_67551_71# vref 0.0316f
C867 m1_70815_71# m1_65375_71# 0.01501f
C868 m1_75343_71# m1_74461_16605# 0
C869 vg m1_71359_71# 0
C870 m1_73167_71# m1_65551_71# 1.01503f
C871 a_64354_200# m1_77519_71# 0.05314f
C872 m1_75343_71# m1_69183_71# 0.04485f
C873 a_79586_200# m1_65375_71# 0.01072f
C874 m1_8353_17355# a_36760_18584# 7.45977f
C875 a_29882_1600# a_122_1600# 1.88723f
C876 m1_7495_451# a_36760_18584# 0.05834f
C877 vg m1_77519_71# 0.07983f
C878 m1_73167_71# m1_72079_71# 1.59231f
C879 m1_82516_7276# m1_69183_71# 0
C880 m1_78607_71# m1_68095_71# 0.04485f
C881 m1_67007_71# a_77410_200# 0.02141f
C882 m1_75343_71# trim3 0.08266f
C883 a_64354_200# m1_69903_71# 6.1485f
C884 a_73058_200# m1_75343_71# 6.15042f
C885 m1_82996_7276# m1_69183_71# 0
C886 a_58170_400# m1_76431_71# 0.0682f
C887 m1_36693_17155# a_36760_18584# 14.16772f
C888 vg m1_69903_71# 0.07579f
C889 rppd$1_6/a_0_0# trim3 0
C890 a_58170_400# a_61534_200# 4.47194f
C891 m1_67551_71# m1_68095_71# 10.43162f
C892 m1_74255_71# m1_66639_71# 0.19373f
C893 e3 e8 0.57216f
C894 m1_67727_71# m1_70991_71# 0.04154f
C895 rppd$2_1/a_0_0# m1_71903_71# 0.05575f
C896 vdd m1_77519_71# 0.10824f
C897 m1_74255_71# m1_71877_16605# 0
C898 m1_70271_71# m1_74255_71# 0.04485f
C899 m1_73167_71# m1_71903_71# 0.04485f
C900 m1_76431_71# m1_74461_16605# 0
C901 rppd$2_10/a_0_0# rppd$2_11/a_0_0# 0.00849f
C902 m1_18655_451# m1_22375_451# 0.14522f
C903 trim2 m1_73167_71# 0.0514f
C904 m1_76431_71# m1_69183_71# 0.04485f
C905 m1_73167_71# m1_64287_71# 0.07237f
C906 m1_74255_71# m1_68639_71# 0.04485f
C907 m1_65551_71# a_36760_18584# 0.05314f
C908 m1_81076_7276# m1_78607_71# 0
C909 vdd m1_69903_71# 0.02818f
C910 m1_65919_71# rppd$2_12/a_0_0# 0.05575f
C911 rppd$1_4/a_0_0# m1_82516_7276# 0.1061f
C912 m1_55_451# a 0.05445f
C913 a_36760_18584# m1_72079_71# 0.05314f
C914 m1_76431_71# trim3 0.08238f
C915 trim3 a_61534_200# 0.04041f
C916 trim0 m1_71359_71# 5.23436f
C917 a_73058_200# m1_76431_71# 6.14987f
C918 a_73058_200# a_61534_200# 0.04041f
C919 a_79586_200# m1_70815_71# 0.01071f
C920 m1_67551_71# m1_81076_7276# 0
C921 trim0 m1_77519_71# 0.04485f
C922 m1_73167_71# m1_66463_71# 0.04485f
C923 m1_69727_71# m1_70991_71# 0.04485f
C924 m1_75343_71# m1_68815_71# 0.22317f
C925 m1_67007_71# m1_65919_71# 0.65161f
C926 m1_67727_71# m1_68095_71# 0.75106f
C927 e3 m1_82516_7276# 0
C928 a_58170_400# m1_65551_71# 0.06351f
C929 m1_71359_71# m1_83476_7276# 0
C930 a_36760_18584# m1_71903_71# 0.01771f
C931 m1_69727_71# vref 0.0316f
C932 trim0 m1_69903_71# 6.2018f
C933 e3 m1_82996_7276# 0
C934 trim2 a_36760_18584# 0.04944f
C935 m1_64463_71# m1_73167_71# 0.1643f
C936 a_58170_400# m1_72079_71# 0.06862f
C937 a_36760_18584# m1_64287_71# 2.92904f
C938 rppd$2_0/a_0_0# m1_71903_71# 0.0369f
C939 m1_65551_71# m1_69183_71# 0.01495f
C940 m1_6169_17355# m1_78607_71# 0.0614f
C941 rppd$1_7/a_0_0# vref 0.00185f
C942 m1_82036_7276# m1_83476_7276# 0
C943 m1_74461_16605# m1_72079_71# 0
C944 a_61534_200# m1_68815_71# 0.04392f
C945 m1_69293_16605# m1_69903_71# 0
C946 m1_72079_71# m1_69183_71# 0.04485f
C947 m1_76431_71# m1_68815_71# 0
C948 vref m1_81556_7276# 0.0013f
C949 m1_65551_71# trim3 0.14531f
C950 m1_74255_71# m1_65375_71# 0.04485f
C951 m1_6169_17355# m1_3775_451# 0.0594f
C952 m1_69727_71# m1_68095_71# 0.01566f
C953 a_73058_200# m1_65551_71# 0.05676f
C954 a_36760_18584# m1_66463_71# 0.01773f
C955 m1_67007_71# a_64354_200# 0.05427f
C956 m1_6169_17355# m1_67551_71# 0.03074f
C957 a_58170_400# m1_71903_71# 0
C958 a_58170_400# trim2 0.08115f
C959 trim3 m1_72079_71# 0.08164f
C960 a_73058_200# m1_72079_71# 0.0566f
C961 m1_73167_71# a_29882_1600# 0.07645f
C962 m1_71903_71# m1_69183_71# 0.0152f
C963 m1_64463_71# a_36760_18584# 0.05314f
C964 m1_81556_7276# m1_68095_71# 0
C965 m1_67007_71# rppd$2_9/a_0_0# 0.0369f
C966 trim2 m1_69183_71# 0.02141f
C967 m1_66639_71# trim1 0.05895f
C968 m1_64287_71# m1_69183_71# 0.02412f
C969 rppd$1_1/a_0_0# m1_83476_7276# 0.33711f
C970 rppd$2_8/a_0_0# rppd$2_9/a_0_0# 0.00849f
C971 m1_70271_71# trim1 0.04282f
C972 trim3 m1_71903_71# 0.01071f
C973 a_73058_200# m1_71903_71# 0.04282f
C974 trim2 trim3 0.1026f
C975 trim1 m1_68639_71# 0.04282f
C976 trim3 m1_64287_71# 0.02071f
C977 a_73058_200# m1_64287_71# 0.07954f
C978 trim2 a_73058_200# 0.34493f
C979 m1_65551_71# m1_68815_71# 0.04154f
C980 m1_67727_71# m1_6169_17355# 0.07492f
C981 m1_66463_71# m1_69183_71# 0.0152f
C982 a_58170_400# m1_64463_71# 0.06351f
C983 m1_14935_451# a_29882_1600# 0.96995f
C984 rppd$1_7/a_0_0# m1_81076_7276# 0.1061f
C985 m1_74255_71# m1_70815_71# 0.04485f
C986 m1_74255_71# a_79586_200# 0.0514f
C987 m1_66639_71# a 0.04485f
C988 m1_72079_71# m1_68815_71# 0.04154f
C989 a_36760_18584# a_29882_1600# 6.8003f
C990 m1_81076_7276# m1_81556_7276# 0.7702f
C991 e8 vref 0.0055f
C992 m1_70271_71# a 0.05288f
C993 m1_64831_71# m1_66639_71# 0.06408f
C994 m1_67007_71# trim0 4.90415f
C995 trim3 m1_66463_71# 0.01071f
C996 m1_64463_71# m1_69183_71# 0.01495f
C997 a_73058_200# m1_66463_71# 0.04282f
C998 m1_70271_71# m1_64831_71# 0.02142f
C999 a m1_68639_71# 0.05288f
C1000 rppd$1_0/a_0_0# rppd$2_14/a_0_0# 0.00849f
C1001 m1_67551_71# m1_78607_71# 0.04485f
C1002 m1_64831_71# m1_68639_71# 0.02149f
C1003 m1_75343_71# m1_70991_71# 0.9043f
C1004 e3 m1_71903_71# 0.06939f
C1005 m1_71903_71# m1_68815_71# 0.01495f
C1006 m1_64463_71# trim3 3.60537f
C1007 m1_67007_71# m1_83476_7276# 0
C1008 m1_69727_71# m1_6169_17355# 0.04464f
C1009 trim2 m1_68815_71# 0.05835f
C1010 e8 m1_68095_71# 0.05076f
C1011 m1_6169_17355# m1_43959_451# 0.07002f
C1012 e3 m1_64287_71# 0.04054f
C1013 a_73058_200# m1_64463_71# 6.16119f
C1014 rppd$2_1/a_0_0# m1_71359_71# 0.0369f
C1015 rppd$2_10/a_0_0# m1_67007_71# 0.05575f
C1016 m1_64287_71# m1_68815_71# 0.07237f
C1017 m1_73167_71# m1_71359_71# 0.04485f
C1018 a_58170_400# a_29882_1600# 0.12284f
C1019 m1_75343_71# vref 0
C1020 vg m1_55_451# 0.07913f
C1021 m1_73167_71# m1_77519_71# 0.25261f
C1022 rppd$1_6/a_0_0# vref 0
C1023 trim1 m1_65375_71# 0.04282f
C1024 m1_66639_71# a_77410_200# 0.05835f
C1025 a_29882_1600# m1_69183_71# 0
C1026 e3 m1_66463_71# 0.08765f
C1027 m1_66463_71# m1_68815_71# 0.04485f
C1028 m1_73167_71# m1_69903_71# 0.04154f
C1029 m1_70271_71# a_77410_200# 0.02141f
C1030 a m1_36887_451# 0.04518f
C1031 m1_76431_71# m1_70991_71# 0.25261f
C1032 m1_83956_7276# a 0.03798f
C1033 m1_75343_71# m1_68095_71# 0.04485f
C1034 a_77410_200# m1_68639_71# 0.02141f
C1035 trim3 a_29882_1600# 0.04714f
C1036 m1_6169_17355# m1_18655_451# 0.05834f
C1037 e8 m1_81076_7276# 0.03861f
C1038 a_73058_200# a_29882_1600# 0.1255f
C1039 m1_64831_71# m1_83956_7276# 0.39755f
C1040 m1_82516_7276# m1_68095_71# 0
C1041 m1_64463_71# m1_68815_71# 0.04141f
C1042 m1_76431_71# vref 0
C1043 a_36760_18584# m1_71359_71# 0.01771f
C1044 a m1_65375_71# 0.05288f
C1045 m1_67727_71# m1_67551_71# 0.12614f
C1046 m1_82996_7276# m1_68095_71# 0
C1047 a_36760_18584# m1_77519_71# 0.05332f
C1048 m1_64831_71# m1_65375_71# 10.49672f
C1049 rppd$2_8/a_0_0# rppd$2_7/a_0_0# 0.00849f
C1050 m1_69727_71# m1_78607_71# 0.04485f
C1051 m1_82036_7276# a_36760_18584# 0
C1052 a_36760_18584# m1_69903_71# 0.05314f
C1053 m1_76431_71# m1_68095_71# 0.04485f
C1054 trim1 m1_70815_71# 0.04282f
C1055 a_58170_400# m1_71359_71# 0
C1056 m1_65919_71# m1_66639_71# 0.04485f
C1057 trim1 a_79586_200# 0.04464f
C1058 rppd$1_6/a_0_0# m1_81076_7276# 0.33711f
C1059 m1_65551_71# m1_70991_71# 0.04134f
C1060 m1_82516_7276# m1_81076_7276# 0
C1061 m1_6169_17355# e8 0.02537f
C1062 e3 a_29882_1600# 0.00263f
C1063 m1_69727_71# m1_67551_71# 0.01535f
C1064 a_29882_1600# m1_68815_71# 0.07729f
C1065 a_58170_400# m1_77519_71# 0.0682f
C1066 m1_70271_71# m1_65919_71# 0.01505f
C1067 m1_82996_7276# m1_81076_7276# 0
C1068 m1_72079_71# m1_70991_71# 1.84341f
C1069 m1_55_451# a_122_1600# 4.09233f
C1070 m1_65919_71# m1_68639_71# 0.0152f
C1071 m1_71359_71# m1_69183_71# 0.01535f
C1072 m1_77519_71# m1_74461_16605# 0
C1073 a_77410_200# m1_65375_71# 0.02141f
C1074 a_58170_400# m1_69903_71# 0.06904f
C1075 m1_77519_71# m1_69183_71# 0.04485f
C1076 a m1_70815_71# 0.05288f
C1077 m1_67551_71# m1_81556_7276# 0
C1078 a a_79586_200# 0.02566f
C1079 trim3 m1_71359_71# 0.01071f
C1080 m1_64831_71# m1_70815_71# 0.02141f
C1081 a_73058_200# m1_71359_71# 0.04282f
C1082 m1_64831_71# a_79586_200# 0.01716f
C1083 m1_67007_71# m1_73167_71# 0.04485f
C1084 m1_82036_7276# m1_69183_71# 0
C1085 m1_6169_17355# m1_75343_71# 0.0614f
C1086 m1_71903_71# m1_70991_71# 0.69622f
C1087 a_64354_200# m1_66639_71# 6.17079f
C1088 m1_69183_71# m1_69903_71# 0.04485f
C1089 trim3 m1_77519_71# 0.08197f
C1090 m1_65551_71# m1_68095_71# 0.01495f
C1091 trim2 m1_70991_71# 0.05835f
C1092 m1_64287_71# m1_70991_71# 0.07237f
C1093 a_73058_200# m1_77519_71# 0.04485f
C1094 vg m1_66639_71# 0.08865f
C1095 m1_70271_71# a_64354_200# 0.02215f
C1096 rppd_0/a_0_0# a_79586_200# 0.00342f
C1097 m1_70271_71# vg 0
C1098 m1_67727_71# m1_69727_71# 0.01497f
C1099 vref m1_71903_71# 0.0316f
C1100 a_64354_200# m1_68639_71# 5.0236f
C1101 trim3 m1_69903_71# 0.08826f
C1102 m1_68095_71# m1_72079_71# 0.04485f
C1103 vg m1_68639_71# 0
C1104 trim2 vref 0.0316f
C1105 m1_22375_451# a_29882_1600# 0.26433f
C1106 a_73058_200# m1_69903_71# 0.05678f
C1107 vref m1_64287_71# 0.05202f
C1108 m1_65919_71# m1_83956_7276# 0
C1109 m1_66639_71# vdd 0.02145f
C1110 m1_66463_71# m1_70991_71# 0.04485f
C1111 m1_6169_17355# m1_29815_451# 0.07002f
C1112 m1_6169_17355# m1_76431_71# 0.0614f
C1113 m1_71877_16605# vdd 0.62724f
C1114 e3 m1_71359_71# 0.0681f
C1115 m1_6169_17355# a_61534_200# 0.06394f
C1116 a_77410_200# m1_70815_71# 0.02141f
C1117 e8 m1_78607_71# 0
C1118 rppd$1_4/a_0_0# m1_82036_7276# 0.33711f
C1119 a_77410_200# a_79586_200# 0.06483f
C1120 m1_71359_71# m1_68815_71# 0.01495f
C1121 m1_71903_71# m1_68095_71# 0.01508f
C1122 m1_65919_71# m1_65375_71# 10.45222f
C1123 m1_67007_71# a_36760_18584# 0.01773f
C1124 vref m1_66463_71# 0.0316f
C1125 trim2 m1_68095_71# 0.02141f
C1126 m1_64287_71# m1_68095_71# 0.02415f
C1127 m1_64463_71# m1_70991_71# 0.0413f
C1128 e8 m1_67551_71# 0.05076f
C1129 m1_7495_451# m1_6169_17355# 0.05834f
C1130 m1_70271_71# rppd$2_5/a_0_0# 0.00366f
C1131 trim0 m1_66639_71# 6.22967f
C1132 vg m1_36887_451# 1.1525f
C1133 m1_74255_71# trim1 6.19974f
C1134 m1_69903_71# m1_68815_71# 2.28485f
C1135 m1_70271_71# trim0 5.15312f
C1136 m1_66463_71# m1_68095_71# 0.01566f
C1137 m1_69727_71# m1_81556_7276# 0
C1138 m1_75343_71# m1_78607_71# 0.28205f
C1139 trim0 m1_68639_71# 0.04356f
C1140 a_64354_200# m1_65375_71# 4.77379f
C1141 m1_67551_71# m1_75343_71# 0.04485f
C1142 m1_81076_7276# m1_64287_71# 0.92948f
C1143 m1_64463_71# m1_68095_71# 0.01495f
C1144 a_29882_1600# m1_70991_71# 0.07729f
C1145 m1_6169_17355# m1_65551_71# 0.07567f
C1146 m1_70271_71# m1_83476_7276# 0
C1147 m1_67007_71# m1_69183_71# 0.01535f
C1148 m1_71877_16605# m1_69293_16605# 0.91614f
C1149 m1_74255_71# a 0.04485f
C1150 m1_83476_7276# m1_68639_71# 0
C1151 m1_67551_71# m1_82516_7276# 0
C1152 m1_65919_71# m1_70815_71# 0.01503f
C1153 m1_6169_17355# m1_72079_71# 0.82306f
C1154 m1_65919_71# a_79586_200# 0.01071f
C1155 m1_64831_71# m1_74255_71# 0.06408f
C1156 vref a_29882_1600# 0.05266f
C1157 m1_67007_71# trim3 0.01071f
C1158 m1_67551_71# m1_82996_7276# 0
C1159 m1_81076_7276# m1_66463_71# 0
C1160 m1_67007_71# a_73058_200# 0.04282f
C1161 m1_76431_71# m1_78607_71# 1.19613f
C1162 vg m1_66709_16605# 0.07936f
C1163 m1_6169_17355# m1_71903_71# 10.5362f
C1164 m1_67551_71# m1_76431_71# 0.04485f
C1165 trim2 m1_6169_17355# 0.06023f
C1166 a_29882_1600# m1_68095_71# 0
C1167 m1_6169_17355# m1_64287_71# 0.02412f
C1168 m1_67727_71# m1_75343_71# 0
C1169 m1_69727_71# e8 0.05075f
C1170 m1_55_451# a_36760_18584# 0.08018f
C1171 a_64354_200# m1_70815_71# 5.18871f
C1172 a_64354_200# a_79586_200# 0.22255f
C1173 m1_7495_451# m1_3775_451# 0.14522f
C1174 trim0 m1_65375_71# 0.07566f
C1175 vg m1_70815_71# 0
C1176 vdd m1_66709_16605# 0.7358f
C1177 vg a_79586_200# 0.12355f
C1178 m1_74255_71# a_77410_200# 0.04977f
C1179 m1_83956_7276# m1_83476_7276# 0.87259f
C1180 m1_67007_71# e3 0.08171f
C1181 m1_67007_71# m1_68815_71# 0.04485f
C1182 m1_6169_17355# m1_66463_71# 0.02774f
C1183 rppd$2_7/a_0_0# m1_68639_71# 0.05575f
C1184 m1_83476_7276# m1_65375_71# 0
C1185 e8 m1_81556_7276# 0.03817f
C1186 m1_71359_71# m1_70991_71# 0.78288f
C1187 vdd a_79586_200# 0.28593f
C1188 m1_69727_71# m1_75343_71# 0.04485f
C1189 m1_67727_71# a_61534_200# 0.06411f
C1190 m1_77519_71# m1_70991_71# 0
C1191 m1_64463_71# m1_6169_17355# 0.07594f
C1192 rppd$2_1/a_0_0# rppd$2_2/a_0_0# 0.00849f
C1193 m1_67551_71# m1_65551_71# 0.01497f
C1194 vref m1_71359_71# 0.0316f
C1195 m1_69727_71# m1_82516_7276# 0
C1196 m1_69903_71# m1_70991_71# 2.06413f
C1197 vref m1_77519_71# 0.28204f
C1198 m1_67551_71# m1_72079_71# 0.04485f
C1199 m1_69727_71# m1_82996_7276# 0
C1200 rppd$1_6/a_0_0# rppd$1_7/a_0_0# 0.15396f
C1201 m1_78607_71# m1_71903_71# 0.04485f
C1202 trim0 m1_70815_71# 0.02215f
C1203 m1_69293_16605# m1_66709_16605# 0.91584f
C1204 a m1_8861_17155# 14.09986f
C1205 trim0 a_79586_200# 0.04437f
C1206 rppd$1_6/a_0_0# m1_81556_7276# 0.1061f
C1207 a trim1 0.05819f
C1208 m1_82516_7276# m1_81556_7276# 0
C1209 trim2 m1_78607_71# 6.2939f
C1210 rppd$2_14/a_0_0# m1_64287_71# 0.03324f
C1211 m1_71359_71# m1_68095_71# 0.01512f
C1212 m1_78607_71# m1_64287_71# 0.07237f
C1213 m1_73167_71# m1_66639_71# 0.87877f
C1214 m1_65919_71# m1_74255_71# 0.04485f
C1215 m1_69727_71# m1_76431_71# 0.04485f
C1216 rppd$2_14/a_0_0# rppd$2_13/a_0_0# 0.00849f
C1217 m1_64831_71# trim1 0.06846f
C1218 m1_70271_71# m1_73167_71# 0.04485f
C1219 m1_73167_71# m1_71877_16605# 0
C1220 m1_67551_71# m1_71903_71# 0.01505f
C1221 m1_82996_7276# m1_81556_7276# 0
C1222 m1_77519_71# m1_68095_71# 0.04485f
C1223 m1_6169_17355# a_29882_1600# 3.6563f
C1224 trim2 m1_67551_71# 0.02141f
C1225 m1_73167_71# m1_68639_71# 0.04485f
C1226 m1_67551_71# m1_64287_71# 0.02416f
C1227 m1_83476_7276# m1_70815_71# 0
C1228 rppd$1_0/a_0_0# m1_64287_71# 0.0106f
C1229 m1_67727_71# m1_65551_71# 0.04184f
C1230 m1_82036_7276# m1_68095_71# 0
C1231 m1_78607_71# m1_66463_71# 0.04485f
C1232 m1_68095_71# m1_69903_71# 0.04485f
C1233 m1_82516_7276# rppd$1_2/a_0_0# 0.06637f
C1234 m1_67727_71# m1_72079_71# 0.04141f
C1235 m1_64831_71# a 0.05288f
C1236 a_64354_200# m1_74255_71# 0.05314f
C1237 m1_82996_7276# rppd$1_2/a_0_0# 0.33711f
C1238 m1_67551_71# m1_66463_71# 0.65806f
C1239 m1_74255_71# vg 0.07496f
C1240 m1_66639_71# a_36760_18584# 0.05314f
C1241 m1_81076_7276# m1_77519_71# 0
C1242 m1_70271_71# a_36760_18584# 0.01771f
C1243 a_77410_200# trim1 8.01921f
C1244 m1_67727_71# m1_71903_71# 0.01495f
C1245 m1_69727_71# m1_65551_71# 0.01495f
C1246 a_36760_18584# m1_68639_71# 0.01771f
C1247 m1_64463_71# m1_67551_71# 0.01495f
C1248 trim2 m1_67727_71# 0.05835f
C1249 m1_67727_71# m1_64287_71# 0.07237f
C1250 m1_82036_7276# m1_81076_7276# 0
C1251 e8 m1_82516_7276# 0.03793f
C1252 rppd$1_3/a_0_0# rppd$1_4/a_0_0# 0.15396f
C1253 m1_69727_71# m1_72079_71# 0.04485f
C1254 m1_74255_71# vdd 0.05056f
C1255 rppd$2_6/a_0_0# m1_68639_71# 0.0369f
C1256 e8 m1_82996_7276# 0.03793f
C1257 m1_67007_71# m1_70991_71# 0.04485f
C1258 a_58170_400# m1_66639_71# 0.06351f
C1259 m1_73167_71# m1_65375_71# 0.04485f
C1260 a_77410_200# a 0.03678f
C1261 m1_78607_71# a_29882_1600# 0.07645f
C1262 m1_6169_17355# m1_71359_71# 0.80106f
C1263 m1_67727_71# m1_66463_71# 0.04485f
C1264 m1_64831_71# a_77410_200# 0.03425f
C1265 m1_67007_71# vref 0.0316f
C1266 m1_69727_71# m1_71903_71# 0.01535f
C1267 m1_66639_71# m1_69183_71# 0.01495f
C1268 e8 m1_76431_71# 0
C1269 m1_6169_17355# m1_77519_71# 0.0614f
C1270 m1_71877_16605# m1_74461_16605# 0.91522f
C1271 m1_67551_71# a_29882_1600# 0
C1272 trim2 m1_69727_71# 0.02141f
C1273 m1_69727_71# m1_64287_71# 0.02412f
C1274 m1_70271_71# m1_69183_71# 0.69032f
C1275 trim0 m1_74255_71# 0.04485f
C1276 m1_67727_71# m1_64463_71# 0.04154f
C1277 a_36760_18584# m1_36887_451# 0.05898f
C1278 trim3 m1_66639_71# 0.11437f
C1279 m1_69183_71# m1_68639_71# 10.42012f
C1280 m1_6169_17355# m1_69903_71# 0.07277f
C1281 m1_65919_71# trim1 0.04282f
C1282 a_73058_200# m1_66639_71# 6.16124f
C1283 rppd$1_7/a_0_0# m1_64287_71# 0.33711f
C1284 m1_70271_71# trim3 0.01071f
C1285 m1_67007_71# m1_68095_71# 0.66451f
C1286 m1_70271_71# a_73058_200# 0.04282f
C1287 m1_82516_7276# m1_82996_7276# 0.83164f
C1288 rppd$2_8/a_0_0# m1_68095_71# 0.05575f
C1289 trim3 m1_68639_71# 0.01071f
C1290 a_36760_18584# m1_65375_71# 0.01774f
C1291 m1_81556_7276# m1_64287_71# 0.09978f
C1292 m1_69727_71# m1_66463_71# 0.01512f
C1293 a_73058_200# m1_68639_71# 0.04282f
C1294 m1_76431_71# m1_75343_71# 0.90736f
C1295 m1_73167_71# m1_70815_71# 0.04485f
C1296 m1_65919_71# a 0.05288f
C1297 m1_73167_71# a_79586_200# 0.0514f
C1298 m1_69727_71# rppd$2_4/a_0_0# 0.0369f
C1299 m1_64463_71# m1_69727_71# 0.01495f
C1300 m1_67727_71# a_29882_1600# 0.07729f
C1301 m1_81556_7276# m1_66463_71# 0
C1302 m1_64831_71# m1_65919_71# 0.64512f
C1303 a_64354_200# trim1 0.37892f
C1304 vg m1_8861_17155# 0.00866f
C1305 rppd$1_2/a_0_0# m1_64287_71# 0
C1306 vg trim1 0.18287f
C1307 m1_67007_71# m1_81076_7276# 0
C1308 m1_66639_71# m1_68815_71# 0.04184f
C1309 m1_83956_7276# m1_69183_71# 0
C1310 m1_78607_71# m1_71359_71# 0.04485f
C1311 m1_70271_71# e3 0.06958f
C1312 m1_70271_71# m1_68815_71# 0.01501f
C1313 m1_78607_71# m1_77519_71# 1.34961f
C1314 e3 m1_68639_71# 0.07327f
C1315 m1_69183_71# m1_65375_71# 0.01508f
C1316 m1_68639_71# m1_68815_71# 0.12582f
C1317 vdd m1_8861_17155# 4.41616f
C1318 m1_67551_71# m1_71359_71# 0.01508f
C1319 vdd trim1 1.25353f
C1320 a_64354_200# a 0.10102f
C1321 a_36760_18584# m1_70815_71# 0.01771f
C1322 e8 m1_71903_71# 0.05843f
C1323 m1_69727_71# a_29882_1600# 0
C1324 m1_67551_71# m1_77519_71# 0.04485f
C1325 vg a 0.80321f
C1326 a_36760_18584# a_79586_200# 0.03592f
C1327 a_64354_200# m1_64831_71# 0.12052f
C1328 trim3 m1_65375_71# 0.01072f
C1329 trim2 e8 0
C1330 e8 m1_64287_71# 1.91397f
C1331 a_29882_1600# m1_43959_451# 5.92988f
C1332 m1_75343_71# m1_72079_71# 0.04154f
C1333 a_73058_200# m1_65375_71# 0.04282f
C1334 m1_65919_71# a_77410_200# 0.02141f
C1335 m1_82036_7276# m1_67551_71# 0
C1336 m1_67551_71# m1_69903_71# 0.04485f
C1337 m1_67007_71# m1_6169_17355# 0.02909f
C1338 vdd a 0.13711p
C1339 m1_8353_17355# m1_36693_17155# 2.9685f
C1340 trim0 trim1 0.13244f
C1341 e8 m1_66463_71# 0.05076f
C1342 a_58170_400# m1_70815_71# 0
C1343 m1_75343_71# m1_71903_71# 0.04485f
C1344 a_58170_400# a_79586_200# 0.06266f
C1345 m1_65551_71# a_61534_200# 0.05578f
C1346 trim2 m1_75343_71# 0.05195f
C1347 e3 m1_83956_7276# 0.55869f
C1348 m1_67727_71# m1_71359_71# 0.01495f
C1349 m1_75343_71# m1_64287_71# 0.07237f
R0 vdd.n3 vdd.n2 127.266
R1 vdd vdd.n8 49.9795
R2 vdd.n8 vdd 48.4747
R3 vdd.n7 vdd 48.4747
R4 vdd.n6 vdd 48.4747
R5 vdd.n5 vdd 40.7745
R6 vdd.n3 vdd 40.7745
R7 vdd.n2 vdd 40.7745
R8 vdd.n1 vdd 40.7745
R9 vdd.n0 vdd 40.7745
R10 vdd.n4 vdd 39.1245
R11 vdd.n4 vdd.n3 27.5445
R12 vdd.n5 vdd.n4 5.6853
R13 vdd.n0 vdd 5.5401
R14 vdd.n1 vdd.n0 4.8053
R15 vdd.n2 vdd.n1 4.8053
R16 vdd.n6 vdd.n5 4.8053
R17 vdd.n7 vdd.n6 1.5053
R18 vdd.n8 vdd.n7 1.5053
R19 vss.n18 vss.n19 0.00206303
R20 vss.n7 vss.n15 619.335
R21 vss.n37 vss.n17 162.034
R22 vss.n39 vss.n26 162.034
R23 vss vss.n11 46.4795
R24 vss vss.n12 10.7456
R25 vss.n43 vss.n16 162.034
R26 vss.n94 vss.n29 162.034
R27 vss.n92 vss.n31 162.034
R28 vss.n90 vss.n33 162.034
R29 vss.n88 vss.n22 162.034
R30 vss.n71 vss.n70 149.504
R31 vss.n84 vss.n23 149.355
R32 vss vss.n19 114.049
R33 vss.n66 vss 77.6929
R34 vss.n67 vss 77.6929
R35 vss.n68 vss 77.6929
R36 vss.n69 vss 77.6929
R37 vss.n70 vss 77.6929
R38 vss.n35 vss.n100 44.2173
R39 vss.n60 vss.n32 44.2163
R40 vss.n95 vss.n28 44.2163
R41 vss.n40 vss.n10 44.2163
R42 vss.n62 vss.n21 44.2154
R43 vss.n58 vss.n30 44.2154
R44 vss.n13 vss.n97 44.2154
R45 vss.n98 vss.n25 44.2154
R46 vss.n101 vss.n18 44.2151
R47 vss.n15 vss 39.1144
R48 vss.n36 vss 35.7974
R49 vss.n99 vss 35.7974
R50 vss.n38 vss 35.7974
R51 vss.n41 vss 35.7974
R52 vss.n96 vss 35.7974
R53 vss.n42 vss 35.7974
R54 vss.n59 vss 35.7974
R55 vss.n61 vss 35.7974
R56 vss.n63 vss 35.7974
R57 vss.n65 vss 35.7974
R58 vss.n64 vss.n44 34.5291
R59 vss.n34 vss.n37 33.4652
R60 vss.n90 vss.n89 33.4619
R61 vss.n92 vss.n91 33.4619
R62 vss.n94 vss.n93 33.4619
R63 vss.n27 vss.n43 33.4619
R64 vss.n11 vss.n10 0.181394
R65 vss.n24 vss.n39 33.4619
R66 vss.n88 vss.n87 33.4569
R67 vss.n66 vss.n65 32.6089
R68 vss.n26 vss.n35 1.05909
R69 vss.n30 vss.n29 1.0585
R70 vss.n86 vss.n85 28.7757
R71 vss.n80 vss.n48 24.8846
R72 vss.n82 vss.n47 23.7868
R73 vss.n79 vss.n49 23.4208
R74 vss.n83 vss.n46 22.689
R75 vss.n78 vss.n50 22.323
R76 vss.n20 vss.n45 21.5911
R77 vss.n77 vss.n51 21.2252
R78 vss.n76 vss.n52 19.7614
R79 vss.n85 vss 19.6272
R80 vss.n84 vss.n7 19.2847
R81 vss vss.n88 18.8945
R82 vss vss.n90 18.8945
R83 vss vss.n92 18.8945
R84 vss vss.n94 18.8945
R85 vss.n43 vss 18.8945
R86 vss.n39 vss 18.8945
R87 vss.n37 vss 18.8945
R88 vss.n75 vss.n53 18.6636
R89 vss vss.n7 4.5774
R90 vss vss.n7 4.57636
R91 vss vss.n7 4.57576
R92 vss.n7 vss 4.57201
R93 vss.n7 vss 4.57201
R94 vss.n7 vss 4.57201
R95 vss.n7 vss 4.57201
R96 vss.n7 vss 4.57201
R97 vss.n8 vss 4.56001
R98 vss.n7 vss 4.5736
R99 vss.n7 vss 4.5736
R100 vss.n7 vss 4.5736
R101 vss.n7 vss 4.5736
R102 vss vss.n7 4.5736
R103 vss vss.n7 4.5736
R104 vss.n7 vss 4.5736
R105 vss.n7 vss 4.57192
R106 vss.n9 vss 4.57775
R107 vss.n9 vss 4.57574
R108 vss.n9 vss.n7 0.00401976
R109 vss.n7 vss 4.5723
R110 vss.n74 vss.n54 17.5658
R111 vss.n25 vss.n26 1.0585
R112 vss.n28 vss.n16 1.05851
R113 vss.n32 vss.n31 1.05851
R114 vss.n21 vss.n33 1.0585
R115 vss.n23 vss.n22 1.05851
R116 vss.n23 vss.n57 17.0005
R117 vss.n23 vss.n56 17.0005
R118 vss.n23 vss.n55 17.0005
R119 vss.n23 vss.n54 17.0005
R120 vss.n23 vss.n53 17.0005
R121 vss.n23 vss.n52 17.0005
R122 vss.n23 vss.n51 17.0005
R123 vss.n23 vss.n50 17.0005
R124 vss.n23 vss.n49 17.0005
R125 vss.n23 vss.n48 17.0005
R126 vss.n23 vss.n47 17.0005
R127 vss.n23 vss.n46 17.0005
R128 vss.n23 vss.n45 17.0005
R129 vss.n7 vss.n20 17.0005
R130 vss.n7 vss.n83 17.0005
R131 vss.n7 vss.n82 17.0005
R132 vss.n7 vss.n80 17.0005
R133 vss.n7 vss.n79 17.0005
R134 vss.n7 vss.n78 17.0005
R135 vss.n7 vss.n77 17.0005
R136 vss.n7 vss.n76 17.0005
R137 vss.n7 vss.n75 17.0005
R138 vss.n7 vss.n74 17.0005
R139 vss.n7 vss.n73 17.0005
R140 vss.n7 vss.n72 17.0005
R141 vss.n7 vss.n14 3.04417
R142 vss.n14 vss.n23 6.83804
R143 vss.n73 vss.n55 16.4679
R144 vss vss.n7 5.43781
R145 vss.n6 vss 9.06025
R146 vss.n29 vss.n28 1.0591
R147 vss.n72 vss.n56 15.0042
R148 vss vss.n5 14.872
R149 vss.n89 vss 14.5569
R150 vss.n91 vss 14.5569
R151 vss.n93 vss 14.5569
R152 vss.n27 vss 14.5569
R153 vss.n10 vss.n12 0.447742
R154 vss.n24 vss 14.5569
R155 vss vss.n34 14.5564
R156 vss.n13 vss 14.5562
R157 vss.n87 vss.n15 14.4621
R158 vss vss.n7 5.78895
R159 vss vss.n4 14.1445
R160 vss.n7 vss 5.9061
R161 vss vss.n3 13.4181
R162 vss vss.n57 13.1744
R163 vss vss.n2 12.6905
R164 vss.n1 vss 12.6886
R165 vss vss.n14 8.17236
R166 vss vss.n7 5.98621
R167 vss.n7 vss 5.992
R168 vss vss.n1 11.9641
R169 vss.n2 vss 11.962
R170 vss vss.n0 11.2419
R171 vss.n3 vss 11.2347
R172 vss.n72 vss.n57 10.9788
R173 vss.n7 vss 5.79152
R174 vss.n7 vss 5.90095
R175 vss.n4 vss 10.508
R176 vss.n7 vss 10.3108
R177 vss.n73 vss.n56 9.88096
R178 vss.n5 vss 9.78074
R179 vss vss.n0 5.89423
R180 vss.n23 vss.n44 9.68719
R181 vss.n74 vss.n55 8.41719
R182 vss vss.n7 5.44591
R183 vss.n6 vss 5.43034
R184 vss.n81 vss.n47 8.28294
R185 vss.n7 vss 5.18811
R186 vss.n75 vss.n54 7.31936
R187 vss.n81 vss.n48 7.18511
R188 vss vss.n7 4.91721
R189 vss.n7 vss 4.906
R190 vss.n76 vss.n53 6.22153
R191 vss vss.n7 4.5736
R192 vss vss.n7 4.5736
R193 vss vss.n7 4.5736
R194 vss vss.n8 4.62829
R195 vss vss.n7 4.57201
R196 vss vss.n7 4.57201
R197 vss vss.n7 4.57201
R198 vss vss.n7 4.57201
R199 vss vss.n7 4.57201
R200 vss vss.n7 4.57212
R201 vss.n7 vss 4.57201
R202 vss vss.n7 4.57201
R203 vss vss.n7 4.57201
R204 vss vss.n7 4.57201
R205 vss.n8 vss.n7 0.0203089
R206 vss vss.n7 4.5736
R207 vss vss.n7 4.5736
R208 vss vss.n7 4.57395
R209 vss.n7 vss 4.57586
R210 vss.n7 vss 4.57465
R211 vss vss.n101 5.78352
R212 vss.n70 vss.n69 5.6853
R213 vss.n69 vss.n68 5.6853
R214 vss.n68 vss.n67 5.6853
R215 vss.n67 vss.n66 5.6853
R216 vss.n23 vss.n86 5.66717
R217 vss.n77 vss.n52 5.1237
R218 vss.n85 vss.n7 4.90895
R219 vss.n7 vss.n81 4.90895
R220 vss vss.n84 4.75776
R221 vss.n78 vss.n51 3.65993
R222 vss.n86 vss.n20 3.29399
R223 vss.n83 vss.n45 3.29399
R224 vss.n79 vss.n50 2.5621
R225 vss.n82 vss.n46 2.19616
R226 vss.n71 vss.n7 28.6894
R227 vss.n64 vss.n63 1.8749
R228 vss.n62 vss.n61 1.8749
R229 vss.n60 vss.n59 1.8749
R230 vss.n58 vss.n42 1.8749
R231 vss.n96 vss.n95 1.8749
R232 vss.n97 vss.n41 1.8749
R233 vss.n40 vss.n38 1.8749
R234 vss.n99 vss.n98 1.8749
R235 vss.n100 vss.n36 1.8749
R236 vss.n80 vss.n49 1.46427
R237 vss.n7 vss 0.819292
R238 vss.n65 vss.n64 1.1621
R239 vss.n63 vss.n62 1.1621
R240 vss.n61 vss.n60 1.1621
R241 vss.n59 vss.n58 1.1621
R242 vss.n95 vss.n42 1.1621
R243 vss.n97 vss.n96 1.1621
R244 vss.n41 vss.n40 1.1621
R245 vss.n98 vss.n38 1.1621
R246 vss.n100 vss.n99 1.1621
R247 vss.n101 vss.n36 1.1621
R248 vss.n18 vss.n17 1.0592
R249 vss.n35 vss.n17 1.0586
R250 vss.n13 vss.n12 1.60835
R251 vss.n13 vss.n16 1.05911
R252 vss.n31 vss.n30 1.05911
R253 vss.n33 vss.n32 1.0591
R254 vss.n22 vss.n21 1.05911
R255 vss.n71 vss 0.0643
R256 vss.n44 vss 0.0181
R257 vss.n7 vss.n1 0.00941264
R258 vss.n7 vss.n3 0.00941264
R259 vss.n7 vss.n5 0.00941264
R260 vss.n7 vss.n0 0.00480504
R261 vss.n7 vss.n2 0.0091618
R262 vss.n7 vss.n4 0.0091618
R263 vss.n7 vss.n6 0.00401502
R264 vss.n89 vss.n21 0.00210961
R265 vss.n91 vss.n32 0.00210961
R266 vss.n93 vss.n30 0.00210961
R267 vss.n28 vss.n27 0.00210961
R268 vss.n25 vss.n24 0.00210961
R269 vss.n87 vss.n23 0.00208887
R270 vss.n35 vss.n34 0.00181917
R271 vss.n19 vss 14.5634
R272 vss.n11 vss.n25 1.93314
R273 trim3 trim3.n0 75.9373
R274 trim3.n0 trim3 71.3529
R275 trim3.n0 trim3 35.9045
R276 trim2 trim2.n1 77.2661
R277 trim2.n0 trim2 70.9129
R278 trim2.n1 trim2 70.9129
R279 trim2.n0 trim2 32.3141
R280 trim2.n1 trim2.n0 2.3941
R281 trim1 trim1.n3 80.9885
R282 trim1.n3 trim1 70.4729
R283 trim1.n2 trim1 70.4729
R284 trim1.n1 trim1 70.4729
R285 trim1.n0 trim1 70.4729
R286 trim1.n0 trim1 23.9365
R287 trim1.n1 trim1.n0 2.3941
R288 trim1.n2 trim1.n1 2.3941
R289 trim1.n3 trim1.n2 2.3941
R290 trim0 trim0.n7 89.4981
R291 trim0.n7 trim0 70.0329
R292 trim0.n6 trim0 70.0329
R293 trim0.n5 trim0 70.0329
R294 trim0.n4 trim0 70.0329
R295 trim0.n3 trim0 70.0329
R296 trim0.n2 trim0 70.0329
R297 trim0.n1 trim0 70.0329
R298 trim0.n0 trim0 70.0329
R299 trim0.n0 trim0 5.9845
R300 trim0.n1 trim0.n0 2.3941
R301 trim0.n2 trim0.n1 2.3941
R302 trim0.n3 trim0.n2 2.3941
R303 trim0.n4 trim0.n3 2.3941
R304 trim0.n5 trim0.n4 2.3941
R305 trim0.n6 trim0.n5 2.3941
R306 trim0.n7 trim0.n6 2.3941
R307 vg vg.n7 104.459
R308 vg.n6 vg 73.0729
R309 vg.n2 vg 73.0729
R310 vg.n1 vg 73.0729
R311 vg.n0 vg 73.0729
R312 vg.n4 vg.n2 60.1221
R313 vg.n5 vg.n4 59.1805
R314 vg.n7 vg 47.1545
R315 vg.n5 vg 44.9065
R316 vg.n4 vg.n3 42.6449
R317 vg.n3 vg 13.9397
R318 vg.n3 vg 9.03814
R319 vg.n6 vg.n5 7.9645
R320 vg.n1 vg.n0 4.8053
R321 vg.n2 vg.n1 4.8053
R322 vg.n0 vg 4.8053
R323 vg.n7 vg.n6 1.8441
R324 m1_71903_71# m1_71903_71.n0 85.1929
R325 m1_71903_71.n0 m1_71903_71# 52.684
R326 m1_71903_71.n0 m1_71903_71# 43.0541
R327 m1_71359_71# m1_71359_71.n0 85.1137
R328 m1_71359_71.n0 m1_71359_71# 52.464
R329 m1_71359_71.n0 m1_71359_71# 42.8341
R330 m1_70815_71# m1_70815_71.n0 85.0345
R331 m1_70815_71.n0 m1_70815_71# 52.244
R332 m1_70815_71.n0 m1_70815_71# 42.6141
R333 m1_70271_71# m1_70271_71.n0 84.9553
R334 m1_70271_71.n0 m1_70271_71# 52.024
R335 m1_70271_71.n0 m1_70271_71# 42.3941
R336 m1_69727_71# m1_69727_71.n0 84.8761
R337 m1_69727_71.n0 m1_69727_71# 51.804
R338 m1_69727_71.n0 m1_69727_71# 42.1741
R339 m1_69183_71# m1_69183_71.n0 84.7969
R340 m1_69183_71.n0 m1_69183_71# 51.584
R341 m1_69183_71.n0 m1_69183_71# 41.9541
R342 m1_68639_71# m1_68639_71.n0 84.7177
R343 m1_68639_71.n0 m1_68639_71# 51.364
R344 m1_68639_71.n0 m1_68639_71# 41.7341
R345 m1_68095_71# m1_68095_71.n0 84.6385
R346 m1_68095_71.n0 m1_68095_71# 51.144
R347 m1_68095_71.n0 m1_68095_71# 41.5141
R348 m1_67551_71# m1_67551_71.n0 84.5593
R349 m1_67551_71.n0 m1_67551_71# 50.924
R350 m1_67551_71.n0 m1_67551_71# 41.2941
R351 m1_67007_71# m1_67007_71.n0 84.4801
R352 m1_67007_71.n0 m1_67007_71# 50.704
R353 m1_67007_71.n0 m1_67007_71# 41.0741
R354 m1_66463_71# m1_66463_71.n0 84.4009
R355 m1_66463_71.n0 m1_66463_71# 50.484
R356 m1_66463_71.n0 m1_66463_71# 40.8541
R357 m1_65919_71# m1_65919_71.n0 84.3217
R358 m1_65919_71.n0 m1_65919_71# 50.264
R359 m1_65919_71.n0 m1_65919_71# 40.6341
R360 m1_65375_71# m1_65375_71.n0 84.2425
R361 m1_65375_71.n0 m1_65375_71# 50.044
R362 m1_65375_71.n0 m1_65375_71# 40.4141
R363 m1_8353_17355.n0 m1_8353_17355# 101.328
R364 m1_8353_17355# m1_8353_17355.n0 87.0185
R365 m1_8353_17355.n0 m1_8353_17355# 40.0969
R366 m1_8353_17355# m1_8353_17355.n1 9.03164
R367 a_79586_200# a_79586_200.n0 82.0425
R368 a_79586_200.n0 a_79586_200# 71.1329
R369 a_79586_200.n0 a_79586_200# 61.9695
R370 a_77410_200# a_77410_200.n1 78.0121
R371 a_77410_200.n1 a_77410_200# 70.6929
R372 a_77410_200.n0 a_77410_200# 70.6929
R373 a_77410_200.n0 a_77410_200# 63.2983
R374 a_77410_200.n1 a_77410_200.n0 2.3941
R375 a_73058_200.n0 a_73058_200# 70.2529
R376 a_73058_200.n1 a_73058_200# 70.2529
R377 a_73058_200.n2 a_73058_200# 70.2529
R378 a_73058_200.n3 a_73058_200# 70.2529
R379 a_73058_200# a_73058_200.n3 69.1945
R380 a_73058_200.n0 a_73058_200# 67.0207
R381 a_73058_200.n3 a_73058_200.n2 2.3941
R382 a_73058_200.n2 a_73058_200.n1 2.3941
R383 a_73058_200.n1 a_73058_200.n0 2.3941
R384 a_64354_200.n0 a_64354_200# 75.5303
R385 a_64354_200.n0 a_64354_200# 69.8129
R386 a_64354_200.n1 a_64354_200# 69.8129
R387 a_64354_200.n2 a_64354_200# 69.8129
R388 a_64354_200.n3 a_64354_200# 69.8129
R389 a_64354_200.n4 a_64354_200# 69.8129
R390 a_64354_200.n5 a_64354_200# 69.8129
R391 a_64354_200.n6 a_64354_200# 69.8129
R392 a_64354_200.n7 a_64354_200# 69.8129
R393 a_64354_200# a_64354_200.n7 50.8025
R394 a_64354_200.n7 a_64354_200.n6 2.3941
R395 a_64354_200.n6 a_64354_200.n5 2.3941
R396 a_64354_200.n5 a_64354_200.n4 2.3941
R397 a_64354_200.n4 a_64354_200.n3 2.3941
R398 a_64354_200.n3 a_64354_200.n2 2.3941
R399 a_64354_200.n2 a_64354_200.n1 2.3941
R400 a_64354_200.n1 a_64354_200.n0 2.3941
R401 a_29882_1600# a_29882_1600.n5 136.31
R402 a_29882_1600.n1 a_29882_1600# 81.6949
R403 a_29882_1600.n5 a_29882_1600# 55.5919
R404 a_29882_1600.n0 a_29882_1600# 55.5919
R405 a_29882_1600.n2 a_29882_1600# 55.5919
R406 a_29882_1600.n1 a_29882_1600# 55.5919
R407 a_29882_1600.n0 a_29882_1600.n4 49.3369
R408 a_29882_1600.n2 a_29882_1600.n1 15.5589
R409 a_29882_1600.n0 a_29882_1600.n2 15.5589
R410 a_29882_1600.n5 a_29882_1600.n0 15.5589
R411 a_29882_1600.n3 a_29882_1600# 13.9564
R412 a_29882_1600.n4 a_29882_1600# 13.9417
R413 a_29882_1600.n3 a_29882_1600# 9.04012
R414 a_29882_1600.n4 a_29882_1600# 9.04012
R415 a_29882_1600.n4 a_29882_1600.n3 4.9021
R416 a_36760_18584.n0 a_36760_18584# 128.435
R417 a_36760_18584# a_36760_18584.n1 102.028
R418 a_36760_18584.n0 a_36760_18584# 72.1751
R419 a_36760_18584.n1 a_36760_18584# 72.1749
R420 a_36760_18584.n1 a_36760_18584.n0 30.6157
R421 a_36760_18584# a_36760_18584.n2 9.03717
R422 a a.n1 201.081
R423 a.n0 a 72.3951
R424 a.n1 a 72.3949
R425 a.n1 a.n0 30.6157
R426 a.n0 a 17.3761
R427 a a.n2 9.01178
R428 vss w_n400_n448.n13 114.053
R429 w_n400_n448.n58 w_n400_n448.n0 619.338
R430 w_n400_n448.n93 w_n400_n448.n28 162.034
R431 w_n400_n448.n76 w_n400_n448.n11 162.034
R432 w_n400_n448.n15 w_n400_n448.n14 162.034
R433 w_n400_n448.n81 w_n400_n448.n8 162.034
R434 w_n400_n448.n6 w_n400_n448.n5 162.034
R435 w_n400_n448.n86 w_n400_n448.n22 162.034
R436 w_n400_n448.n19 w_n400_n448.n18 162.034
R437 w_n400_n448.n92 w_n400_n448.n23 162.034
R438 w_n400_n448.n95 w_n400_n448.n27 162.034
R439 w_n400_n448.n61 w_n400_n448.n60 149.504
R440 w_n400_n448.n97 w_n400_n448.n30 149.352
R441 w_n400_n448.n65 vss 77.6929
R442 w_n400_n448.n64 vss 77.6929
R443 w_n400_n448.n63 vss 77.6929
R444 w_n400_n448.n62 vss 77.6929
R445 w_n400_n448.n61 vss 77.6929
R446 w_n400_n448.n77 w_n400_n448.n17 44.2162
R447 w_n400_n448.n82 w_n400_n448.n10 44.2162
R448 w_n400_n448.n87 w_n400_n448.n21 44.2162
R449 w_n400_n448.n26 w_n400_n448.n71 44.2162
R450 w_n400_n448.n69 w_n400_n448.n31 44.216
R451 w_n400_n448.n12 w_n400_n448.n75 44.2154
R452 w_n400_n448.n7 w_n400_n448.n79 44.2151
R453 w_n400_n448.n32 w_n400_n448.n84 44.2151
R454 w_n400_n448.n24 w_n400_n448.n90 44.2151
R455 w_n400_n448.n58 vss 39.1144
R456 w_n400_n448.n74 vss 35.7974
R457 w_n400_n448.n78 vss 35.7974
R458 w_n400_n448.n73 vss 35.7974
R459 w_n400_n448.n83 vss 35.7974
R460 w_n400_n448.n72 vss 35.7974
R461 w_n400_n448.n88 vss 35.7974
R462 w_n400_n448.n89 vss 35.7974
R463 w_n400_n448.n70 vss 35.7974
R464 w_n400_n448.n68 vss 35.7974
R465 w_n400_n448.n66 vss 35.7974
R466 w_n400_n448.n67 w_n400_n448.n59 34.5291
R467 w_n400_n448.n95 w_n400_n448.n94 33.4657
R468 w_n400_n448.n20 w_n400_n448.n86 33.4624
R469 w_n400_n448.n9 w_n400_n448.n81 33.4624
R470 w_n400_n448.n16 w_n400_n448.n76 33.4624
R471 w_n400_n448.n25 w_n400_n448.n92 33.4619
R472 w_n400_n448.n91 w_n400_n448.n18 33.4619
R473 w_n400_n448.n85 w_n400_n448.n5 33.4619
R474 w_n400_n448.n80 w_n400_n448.n14 33.4619
R475 w_n400_n448.n93 w_n400_n448.n29 33.4619
R476 w_n400_n448.n66 w_n400_n448.n65 32.6089
R477 w_n400_n448.n24 w_n400_n448.n23 1.05911
R478 w_n400_n448.n8 w_n400_n448.n7 1.05911
R479 w_n400_n448.n22 w_n400_n448.n21 1.05851
R480 w_n400_n448.n22 w_n400_n448.n32 1.05911
R481 w_n400_n448.n31 w_n400_n448.n27 1.05852
R482 w_n400_n448.n99 w_n400_n448.n98 28.7757
R483 w_n400_n448.n39 w_n400_n448.n38 24.8846
R484 w_n400_n448.n37 w_n400_n448.n36 23.7868
R485 w_n400_n448.n42 w_n400_n448.n41 23.4208
R486 w_n400_n448.n35 w_n400_n448.n34 22.689
R487 w_n400_n448.n44 w_n400_n448.n43 22.323
R488 w_n400_n448.n96 w_n400_n448.n33 21.5911
R489 w_n400_n448.n46 w_n400_n448.n45 21.2252
R490 w_n400_n448.n48 w_n400_n448.n47 19.7614
R491 w_n400_n448.n98 vss 19.6272
R492 w_n400_n448.n97 w_n400_n448.n0 19.2835
R493 vss w_n400_n448.n93 18.8945
R494 vss w_n400_n448.n95 18.8945
R495 w_n400_n448.n92 vss 18.8945
R496 vss w_n400_n448.n18 18.8945
R497 w_n400_n448.n86 vss 18.8945
R498 vss w_n400_n448.n5 18.8945
R499 w_n400_n448.n81 vss 18.8945
R500 vss w_n400_n448.n14 18.8945
R501 w_n400_n448.n76 vss 18.8945
R502 w_n400_n448.n50 w_n400_n448.n49 18.6636
R503 w_n400_n448.n0 vss 4.57678
R504 w_n400_n448.n0 vss 4.57365
R505 w_n400_n448.n0 vss 4.57365
R506 w_n400_n448.n0 vss 4.57365
R507 w_n400_n448.n0 vss 4.57365
R508 w_n400_n448.n0 vss 4.57365
R509 w_n400_n448.n0 vss 4.57365
R510 w_n400_n448.n0 vss 4.57365
R511 w_n400_n448.n0 vss 4.57355
R512 w_n400_n448.n52 w_n400_n448.n51 17.5658
R513 w_n400_n448.n96 w_n400_n448.n0 17.0005
R514 w_n400_n448.n34 w_n400_n448.n0 17.0005
R515 w_n400_n448.n36 w_n400_n448.n0 17.0005
R516 w_n400_n448.n38 w_n400_n448.n0 17.0005
R517 w_n400_n448.n42 w_n400_n448.n0 17.0005
R518 w_n400_n448.n44 w_n400_n448.n0 17.0005
R519 w_n400_n448.n46 w_n400_n448.n0 17.0005
R520 w_n400_n448.n48 w_n400_n448.n0 17.0005
R521 w_n400_n448.n50 w_n400_n448.n0 17.0005
R522 w_n400_n448.n52 w_n400_n448.n0 17.0005
R523 w_n400_n448.n54 w_n400_n448.n0 17.0005
R524 w_n400_n448.n56 w_n400_n448.n0 17.0005
R525 w_n400_n448.n4 w_n400_n448.n0 3.04402
R526 w_n400_n448.n30 w_n400_n448.n57 17.0005
R527 w_n400_n448.n30 w_n400_n448.n55 17.0005
R528 w_n400_n448.n30 w_n400_n448.n53 17.0005
R529 w_n400_n448.n30 w_n400_n448.n51 17.0005
R530 w_n400_n448.n30 w_n400_n448.n49 17.0005
R531 w_n400_n448.n30 w_n400_n448.n47 17.0005
R532 w_n400_n448.n30 w_n400_n448.n45 17.0005
R533 w_n400_n448.n30 w_n400_n448.n43 17.0005
R534 w_n400_n448.n30 w_n400_n448.n41 17.0005
R535 w_n400_n448.n30 w_n400_n448.n39 17.0005
R536 w_n400_n448.n30 w_n400_n448.n37 17.0005
R537 w_n400_n448.n30 w_n400_n448.n35 17.0005
R538 w_n400_n448.n30 w_n400_n448.n33 17.0005
R539 w_n400_n448.n17 w_n400_n448.n11 1.05851
R540 w_n400_n448.n7 w_n400_n448.n15 1.0585
R541 w_n400_n448.n54 w_n400_n448.n53 16.4679
R542 w_n400_n448.n2 vss 8.33247
R543 vss w_n400_n448.n0 5.43728
R544 w_n400_n448.n0 vss 5.44491
R545 vss w_n400_n448.n105 15.5992
R546 w_n400_n448.n27 w_n400_n448.n26 1.05911
R547 w_n400_n448.n56 w_n400_n448.n55 15.0042
R548 vss w_n400_n448.n104 14.8722
R549 w_n400_n448.n25 vss 14.5569
R550 vss w_n400_n448.n91 14.5569
R551 vss w_n400_n448.n85 14.5569
R552 vss w_n400_n448.n80 14.5569
R553 w_n400_n448.n20 vss 14.5562
R554 w_n400_n448.n9 vss 14.5562
R555 w_n400_n448.n16 vss 14.5562
R556 vss w_n400_n448.n13 14.5568
R557 w_n400_n448.n94 vss 14.5562
R558 w_n400_n448.n29 w_n400_n448.n58 14.4572
R559 w_n400_n448.n0 vss 4.57656
R560 vss w_n400_n448.n103 14.1452
R561 w_n400_n448.n30 w_n400_n448.n4 6.8377
R562 vss w_n400_n448.n102 13.4183
R563 w_n400_n448.n3 vss 5.8937
R564 vss w_n400_n448.n57 13.1744
R565 vss w_n400_n448.n101 12.6913
R566 w_n400_n448.n100 vss 12.6878
R567 w_n400_n448.n4 vss 8.17246
R568 vss w_n400_n448.n0 5.99219
R569 vss w_n400_n448.n0 5.9861
R570 vss w_n400_n448.n100 11.9644
R571 w_n400_n448.n101 vss 11.9608
R572 vss w_n400_n448.n3 11.2428
R573 w_n400_n448.n102 vss 11.2339
R574 w_n400_n448.n57 w_n400_n448.n56 10.9788
R575 w_n400_n448.n0 vss 5.9009
R576 w_n400_n448.n103 vss 10.5069
R577 vss w_n400_n448.n0 10.3109
R578 w_n400_n448.n55 w_n400_n448.n54 9.88096
R579 w_n400_n448.n0 vss 5.78911
R580 w_n400_n448.n0 vss 5.79095
R581 w_n400_n448.n104 vss 9.77995
R582 w_n400_n448.n3 w_n400_n448.n0 0.00483191
R583 w_n400_n448.n30 w_n400_n448.n59 9.6892
R584 w_n400_n448.n105 vss 9.05298
R585 w_n400_n448.n41 w_n400_n448.n40 8.64888
R586 w_n400_n448.n53 w_n400_n448.n52 8.41719
R587 w_n400_n448.n2 vss 5.18765
R588 w_n400_n448.n51 w_n400_n448.n50 7.31936
R589 w_n400_n448.n40 w_n400_n448.n39 7.18511
R590 vss w_n400_n448.n0 4.91833
R591 w_n400_n448.n0 vss 4.90543
R592 w_n400_n448.n49 w_n400_n448.n48 6.22153
R593 w_n400_n448.n0 vss 4.57605
R594 w_n400_n448.n0 vss 4.57777
R595 vss w_n400_n448.n0 4.57365
R596 vss w_n400_n448.n0 4.57365
R597 vss w_n400_n448.n0 4.57365
R598 vss w_n400_n448.n1 4.5594
R599 vss w_n400_n448.n0 4.57218
R600 vss w_n400_n448.n0 4.57218
R601 w_n400_n448.n0 vss 4.57218
R602 w_n400_n448.n0 vss 4.57218
R603 w_n400_n448.n0 vss 4.57218
R604 vss w_n400_n448.n0 4.57218
R605 vss w_n400_n448.n0 4.57218
R606 vss w_n400_n448.n0 4.57218
R607 vss w_n400_n448.n0 4.57218
R608 vss w_n400_n448.n0 4.57222
R609 w_n400_n448.n75 vss 5.78352
R610 w_n400_n448.n62 w_n400_n448.n61 5.6853
R611 w_n400_n448.n63 w_n400_n448.n62 5.6853
R612 w_n400_n448.n64 w_n400_n448.n63 5.6853
R613 w_n400_n448.n65 w_n400_n448.n64 5.6853
R614 w_n400_n448.n30 w_n400_n448.n99 5.66717
R615 w_n400_n448.n47 w_n400_n448.n46 5.1237
R616 w_n400_n448.n98 w_n400_n448.n0 4.90895
R617 w_n400_n448.n40 w_n400_n448.n0 4.90895
R618 vss w_n400_n448.n97 4.75776
R619 w_n400_n448.n45 w_n400_n448.n44 3.65993
R620 w_n400_n448.n99 w_n400_n448.n96 3.29399
R621 w_n400_n448.n34 w_n400_n448.n33 3.29399
R622 w_n400_n448.n43 w_n400_n448.n42 2.5621
R623 w_n400_n448.n36 w_n400_n448.n35 2.19616
R624 w_n400_n448.n60 w_n400_n448.n0 28.77
R625 w_n400_n448.n68 w_n400_n448.n67 1.8749
R626 w_n400_n448.n70 w_n400_n448.n69 1.8749
R627 w_n400_n448.n89 w_n400_n448.n71 1.8749
R628 w_n400_n448.n90 w_n400_n448.n88 1.8749
R629 w_n400_n448.n87 w_n400_n448.n72 1.8749
R630 w_n400_n448.n84 w_n400_n448.n83 1.8749
R631 w_n400_n448.n82 w_n400_n448.n73 1.8749
R632 w_n400_n448.n79 w_n400_n448.n78 1.8749
R633 w_n400_n448.n77 w_n400_n448.n74 1.8749
R634 w_n400_n448.n0 vss 0.849112
R635 w_n400_n448.n67 w_n400_n448.n66 1.1621
R636 w_n400_n448.n69 w_n400_n448.n68 1.1621
R637 w_n400_n448.n71 w_n400_n448.n70 1.1621
R638 w_n400_n448.n90 w_n400_n448.n89 1.1621
R639 w_n400_n448.n88 w_n400_n448.n87 1.1621
R640 w_n400_n448.n84 w_n400_n448.n72 1.1621
R641 w_n400_n448.n83 w_n400_n448.n82 1.1621
R642 w_n400_n448.n79 w_n400_n448.n73 1.1621
R643 w_n400_n448.n78 w_n400_n448.n77 1.1621
R644 w_n400_n448.n75 w_n400_n448.n74 1.1621
R645 w_n400_n448.n38 w_n400_n448.n37 1.09833
R646 w_n400_n448.n31 w_n400_n448.n28 1.05948
R647 w_n400_n448.n12 w_n400_n448.n11 1.05911
R648 w_n400_n448.n17 w_n400_n448.n15 1.0591
R649 w_n400_n448.n10 w_n400_n448.n6 1.0591
R650 w_n400_n448.n21 w_n400_n448.n19 1.0591
R651 w_n400_n448.n30 w_n400_n448.n28 1.05888
R652 w_n400_n448.n10 w_n400_n448.n8 1.05851
R653 w_n400_n448.n32 w_n400_n448.n6 1.0585
R654 w_n400_n448.n24 w_n400_n448.n19 1.0585
R655 w_n400_n448.n26 w_n400_n448.n23 1.05851
R656 w_n400_n448.n60 vss 0.0643
R657 w_n400_n448.n59 vss 0.0181
R658 w_n400_n448.n100 w_n400_n448.n0 0.00922304
R659 w_n400_n448.n101 w_n400_n448.n0 0.00922304
R660 w_n400_n448.n102 w_n400_n448.n0 0.00922304
R661 w_n400_n448.n103 w_n400_n448.n0 0.00922304
R662 w_n400_n448.n104 w_n400_n448.n0 0.00922304
R663 w_n400_n448.n105 w_n400_n448.n0 0.00922304
R664 w_n400_n448.n2 w_n400_n448.n0 0.00377131
R665 vss w_n400_n448.n0 4.57365
R666 vss w_n400_n448.n0 4.57365
R667 vss w_n400_n448.n0 4.57365
R668 vss w_n400_n448.n0 4.57365
R669 vss w_n400_n448.n0 4.57365
R670 vss w_n400_n448.n0 4.57365
R671 vss w_n400_n448.n1 4.59427
R672 w_n400_n448.n1 w_n400_n448.n0 0.0590971
R673 vss w_n400_n448.n0 4.57218
R674 vss w_n400_n448.n0 4.57218
R675 vss w_n400_n448.n0 4.57218
R676 vss w_n400_n448.n0 4.57218
R677 vss w_n400_n448.n0 4.57218
R678 w_n400_n448.n94 w_n400_n448.n31 0.00226269
R679 w_n400_n448.n26 w_n400_n448.n25 0.00210961
R680 w_n400_n448.n91 w_n400_n448.n24 0.00210961
R681 w_n400_n448.n80 w_n400_n448.n7 0.00210961
R682 w_n400_n448.n85 w_n400_n448.n32 0.00210954
R683 w_n400_n448.n30 w_n400_n448.n29 0.00208069
R684 w_n400_n448.n21 w_n400_n448.n20 0.0019792
R685 w_n400_n448.n17 w_n400_n448.n16 0.0019792
R686 w_n400_n448.n13 w_n400_n448.n12 0.00245023
R687 w_n400_n448.n10 w_n400_n448.n9 0.0019792
R688 vss w_n400_n448.n0 4.57601
R689 vss w_n400_n448.n0 5.90541
C1350 w_n400_n448.n0 vss 9.83695f ; **FLOATING
C1351 w_n400_n448.n1 vss 0.0509f ; **FLOATING
C1352 w_n400_n448.n2 vss 0.04437f ; **FLOATING
C1353 w_n400_n448.n3 vss 0.04501f ; **FLOATING
C1354 w_n400_n448.n4 vss 0.00217f ; **FLOATING
C1355 w_n400_n448.n5 vss 0.02285f ; **FLOATING
C1356 w_n400_n448.n6 vss 0 ; **FLOATING
C1357 w_n400_n448.n7 vss 0.01632f ; **FLOATING
C1358 w_n400_n448.n8 vss 0 ; **FLOATING
C1359 w_n400_n448.n9 vss 0.1469f ; **FLOATING
C1360 w_n400_n448.n10 vss 0.01632f ; **FLOATING
C1361 w_n400_n448.n11 vss 0 ; **FLOATING
C1362 w_n400_n448.n12 vss 0.06282f ; **FLOATING
C1363 w_n400_n448.n13 vss 0.18168f ; **FLOATING
C1364 w_n400_n448.n14 vss 0.02285f ; **FLOATING
C1365 w_n400_n448.n15 vss 0 ; **FLOATING
C1366 w_n400_n448.n16 vss 0.1469f ; **FLOATING
C1367 w_n400_n448.n17 vss 0.01632f ; **FLOATING
C1368 w_n400_n448.n18 vss 0.02285f ; **FLOATING
C1369 w_n400_n448.n19 vss 0 ; **FLOATING
C1370 w_n400_n448.n20 vss 0.1469f ; **FLOATING
C1371 w_n400_n448.n21 vss 0.01632f ; **FLOATING
C1372 w_n400_n448.n22 vss 0 ; **FLOATING
C1373 w_n400_n448.n23 vss 0 ; **FLOATING
C1374 w_n400_n448.n24 vss 0.01632f ; **FLOATING
C1375 w_n400_n448.n25 vss 0.1469f ; **FLOATING
C1376 w_n400_n448.n26 vss 0.01632f ; **FLOATING
C1377 w_n400_n448.n27 vss 0 ; **FLOATING
C1378 w_n400_n448.n28 vss 0 ; **FLOATING
C1379 w_n400_n448.n29 vss 0.11281f ; **FLOATING
C1380 w_n400_n448.n30 vss 0.01811f ; **FLOATING
C1381 w_n400_n448.n31 vss 0.01632f ; **FLOATING
C1382 w_n400_n448.n32 vss 0.01632f ; **FLOATING
C1383 w_n400_n448.n33 vss 0.00208f ; **FLOATING
C1384 w_n400_n448.n34 vss 0.00217f ; **FLOATING
C1385 w_n400_n448.n35 vss 0.00208f ; **FLOATING
C1386 w_n400_n448.n36 vss 0.00217f ; **FLOATING
C1387 w_n400_n448.n37 vss 0.00208f ; **FLOATING
C1388 w_n400_n448.n38 vss 0.00217f ; **FLOATING
C1389 w_n400_n448.n39 vss 0.00416f ; **FLOATING
C1390 w_n400_n448.n40 vss 0 ; **FLOATING
C1391 w_n400_n448.n41 vss 0.00391f ; **FLOATING
C1392 w_n400_n448.n42 vss 0.00217f ; **FLOATING
C1393 w_n400_n448.n43 vss 0.00208f ; **FLOATING
C1394 w_n400_n448.n44 vss 0.00217f ; **FLOATING
C1395 w_n400_n448.n45 vss 0.00208f ; **FLOATING
C1396 w_n400_n448.n46 vss 0.0022f ; **FLOATING
C1397 w_n400_n448.n47 vss 0.00208f ; **FLOATING
C1398 w_n400_n448.n48 vss 0.00217f ; **FLOATING
C1399 w_n400_n448.n49 vss 0.00208f ; **FLOATING
C1400 w_n400_n448.n50 vss 0.00217f ; **FLOATING
C1401 w_n400_n448.n51 vss 0.00208f ; **FLOATING
C1402 w_n400_n448.n52 vss 0.00217f ; **FLOATING
C1403 w_n400_n448.n53 vss 0.00208f ; **FLOATING
C1404 w_n400_n448.n54 vss 0.0022f ; **FLOATING
C1405 w_n400_n448.n55 vss 0.00208f ; **FLOATING
C1406 w_n400_n448.n56 vss 0.00217f ; **FLOATING
C1407 w_n400_n448.n57 vss 0.00202f ; **FLOATING
C1408 w_n400_n448.n58 vss 0.63298f ; **FLOATING
C1409 w_n400_n448.n59 vss 0.00122f ; **FLOATING
C1410 w_n400_n448.n60 vss 0.02298f ; **FLOATING
C1411 w_n400_n448.n61 vss 0.04334f ; **FLOATING
C1412 w_n400_n448.n62 vss 0.00285f ; **FLOATING
C1413 w_n400_n448.n63 vss 0.00285f ; **FLOATING
C1414 w_n400_n448.n64 vss 0.00285f ; **FLOATING
C1415 w_n400_n448.n65 vss 0.00467f ; **FLOATING
C1416 w_n400_n448.n66 vss 0.00351f ; **FLOATING
C1417 w_n400_n448.n67 vss 0.00134f ; **FLOATING
C1418 w_n400_n448.n68 vss 0.00143f ; **FLOATING
C1419 w_n400_n448.n69 vss 0.00161f ; **FLOATING
C1420 w_n400_n448.n70 vss 0.00143f ; **FLOATING
C1421 w_n400_n448.n71 vss 0.00161f ; **FLOATING
C1422 w_n400_n448.n72 vss 0.00143f ; **FLOATING
C1423 w_n400_n448.n73 vss 0.00143f ; **FLOATING
C1424 w_n400_n448.n74 vss 0.00143f ; **FLOATING
C1425 w_n400_n448.n75 vss 0.00186f ; **FLOATING
C1426 w_n400_n448.n76 vss 0.02285f ; **FLOATING
C1427 w_n400_n448.n77 vss 0.00161f ; **FLOATING
C1428 w_n400_n448.n78 vss 0.00143f ; **FLOATING
C1429 w_n400_n448.n79 vss 0.00161f ; **FLOATING
C1430 w_n400_n448.n80 vss 0.1469f ; **FLOATING
C1431 w_n400_n448.n81 vss 0.02285f ; **FLOATING
C1432 w_n400_n448.n82 vss 0.00161f ; **FLOATING
C1433 w_n400_n448.n83 vss 0.00143f ; **FLOATING
C1434 w_n400_n448.n84 vss 0.00161f ; **FLOATING
C1435 w_n400_n448.n85 vss 0.1469f ; **FLOATING
C1436 w_n400_n448.n86 vss 0.02285f ; **FLOATING
C1437 w_n400_n448.n87 vss 0.00161f ; **FLOATING
C1438 w_n400_n448.n88 vss 0.00143f ; **FLOATING
C1439 w_n400_n448.n89 vss 0.00143f ; **FLOATING
C1440 w_n400_n448.n90 vss 0.00161f ; **FLOATING
C1441 w_n400_n448.n91 vss 0.1469f ; **FLOATING
C1442 w_n400_n448.n92 vss 0.02285f ; **FLOATING
C1443 w_n400_n448.n93 vss 0.02285f ; **FLOATING
C1444 w_n400_n448.n94 vss 0.1469f ; **FLOATING
C1445 w_n400_n448.n95 vss 0.02286f ; **FLOATING
C1446 w_n400_n448.n96 vss 0.00208f ; **FLOATING
C1447 w_n400_n448.n97 vss 0.00391f ; **FLOATING
C1448 w_n400_n448.n98 vss 0.00489f ; **FLOATING
C1449 w_n400_n448.n99 vss 0.00305f ; **FLOATING
C1450 w_n400_n448.n100 vss 0.04507f ; **FLOATING
C1451 w_n400_n448.n101 vss 0.04507f ; **FLOATING
C1452 w_n400_n448.n102 vss 0.04503f ; **FLOATING
C1453 w_n400_n448.n103 vss 0.04495f ; **FLOATING
C1454 w_n400_n448.n104 vss 0.04482f ; **FLOATING
C1455 w_n400_n448.n105 vss 0.04464f ; **FLOATING
C1456 a.n0 vss 1.28329f ; **FLOATING
C1457 a.n1 vss 4.09876f ; **FLOATING
C1458 a.n2 vss 0.26619f ; **FLOATING
C1459 a_36760_18584.n0 vss 1.75465f ; **FLOATING
C1460 a_36760_18584.n1 vss 1.5551f ; **FLOATING
C1461 a_36760_18584.n2 vss 0.03059f ; **FLOATING
C1462 a_29882_1600.n0 vss 0.19483f ; **FLOATING
C1463 a_29882_1600.n1 vss 0.27282f ; **FLOATING
C1464 a_29882_1600.n2 vss 0.14883f ; **FLOATING
C1465 a_29882_1600.n3 vss 0.07012f ; **FLOATING
C1466 a_29882_1600.n4 vss 0.09348f ; **FLOATING
C1467 a_29882_1600.n5 vss 0.43518f ; **FLOATING
C1468 a_64354_200.n0 vss 15.1413f ; **FLOATING
C1469 a_64354_200.n1 vss 7.37291f ; **FLOATING
C1470 a_64354_200.n2 vss 7.37291f ; **FLOATING
C1471 a_64354_200.n3 vss 7.37291f ; **FLOATING
C1472 a_64354_200.n4 vss 7.37291f ; **FLOATING
C1473 a_64354_200.n5 vss 7.37291f ; **FLOATING
C1474 a_64354_200.n6 vss 7.37291f ; **FLOATING
C1475 a_64354_200.n7 vss 12.9449f ; **FLOATING
C1476 a_73058_200.n0 vss 14.0021f ; **FLOATING
C1477 a_73058_200.n1 vss 7.93806f ; **FLOATING
C1478 a_73058_200.n2 vss 7.93806f ; **FLOATING
C1479 a_73058_200.n3 vss 18.0086f ; **FLOATING
C1480 a_77410_200.n0 vss 12.5465f ; **FLOATING
C1481 a_77410_200.n1 vss 19.1165f ; **FLOATING
C1482 a_79586_200.n0 vss 23.3875f ; **FLOATING
C1483 m1_8353_17355.n0 vss 9.57505f ; **FLOATING
C1484 m1_8353_17355.n1 vss 1.02127f ; **FLOATING
C1485 m1_65375_71.n0 vss 15.612f ; **FLOATING
C1486 m1_65919_71.n0 vss 15.6172f ; **FLOATING
C1487 m1_66463_71.n0 vss 15.6216f ; **FLOATING
C1488 m1_67007_71.n0 vss 15.6292f ; **FLOATING
C1489 m1_67551_71.n0 vss 15.6434f ; **FLOATING
C1490 m1_68095_71.n0 vss 15.6385f ; **FLOATING
C1491 m1_68639_71.n0 vss 15.6403f ; **FLOATING
C1492 m1_69183_71.n0 vss 15.6496f ; **FLOATING
C1493 m1_69727_71.n0 vss 15.661f ; **FLOATING
C1494 m1_70271_71.n0 vss 15.6837f ; **FLOATING
C1495 m1_70815_71.n0 vss 15.6788f ; **FLOATING
C1496 m1_71359_71.n0 vss 15.7035f ; **FLOATING
C1497 m1_71903_71.n0 vss 15.4864f ; **FLOATING
C1498 vg.n0 vss 0.43152f ; **FLOATING
C1499 vg.n1 vss 0.43152f ; **FLOATING
C1500 vg.n2 vss 1.14988f ; **FLOATING
C1501 vg.n3 vss 0.56756f ; **FLOATING
C1502 vg.n4 vss 1.87098f ; **FLOATING
C1503 vg.n5 vss 1.22294f ; **FLOATING
C1504 vg.n6 vss 0.43409f ; **FLOATING
C1505 vg.n7 vss 1.13987f ; **FLOATING
C1506 trim0.n0 vss 8.54666f ; **FLOATING
C1507 trim0.n1 vss 7.88748f ; **FLOATING
C1508 trim0.n2 vss 7.88748f ; **FLOATING
C1509 trim0.n3 vss 7.88748f ; **FLOATING
C1510 trim0.n4 vss 7.88748f ; **FLOATING
C1511 trim0.n5 vss 7.88748f ; **FLOATING
C1512 trim0.n6 vss 7.88748f ; **FLOATING
C1513 trim0.n7 vss 16.3736f ; **FLOATING
C1514 trim1.n0 vss 12.4868f ; **FLOATING
C1515 trim1.n1 vss 8.3504f ; **FLOATING
C1516 trim1.n2 vss 8.3504f ; **FLOATING
C1517 trim1.n3 vss 14.7854f ; **FLOATING
C1518 trim2.n0 vss 13.8875f ; **FLOATING
C1519 trim2.n1 vss 13.4742f ; **FLOATING
C1520 trim3.n0 vss 17.3553f ; **FLOATING
C1521 vss.n0 vss 0.30156f ; **FLOATING
C1522 vss.n1 vss 0.30196f ; **FLOATING
C1523 vss.n2 vss 0.30197f ; **FLOATING
C1524 vss.n3 vss 0.3017f ; **FLOATING
C1525 vss.n4 vss 0.30116f ; **FLOATING
C1526 vss.n5 vss 0.3003f ; **FLOATING
C1527 vss.n6 vss 0.29891f ; **FLOATING
C1528 vss.n7 vss 65.8652f ; **FLOATING
C1529 vss.n8 vss 0.33851f ; **FLOATING
C1530 vss.n9 vss 0.34199f ; **FLOATING
C1531 vss.n10 vss 1.09452f ; **FLOATING
C1532 vss.n11 vss 0.06329f ; **FLOATING
C1533 vss.n12 vss 0.00712f ; **FLOATING
C1534 vss.n13 vss 1.14985f ; **FLOATING
C1535 vss.n14 vss 0.01457f ; **FLOATING
C1536 vss.n15 vss 4.24127f ; **FLOATING
C1537 vss.n16 vss 0.00192f ; **FLOATING
C1538 vss.n17 vss 0.00192f ; **FLOATING
C1539 vss.n18 vss 0.42094f ; **FLOATING
C1540 vss.n19 vss 1.21715f ; **FLOATING
C1541 vss.n20 vss 0.01394f ; **FLOATING
C1542 vss.n21 vss 0.10937f ; **FLOATING
C1543 vss.n22 vss 0.00192f ; **FLOATING
C1544 vss.n23 vss 0.12147f ; **FLOATING
C1545 vss.n24 vss 0.98429f ; **FLOATING
C1546 vss.n25 vss 0.11023f ; **FLOATING
C1547 vss.n26 vss 0.00192f ; **FLOATING
C1548 vss.n27 vss 0.98429f ; **FLOATING
C1549 vss.n28 vss 0.10937f ; **FLOATING
C1550 vss.n29 vss 0.00192f ; **FLOATING
C1551 vss.n30 vss 0.10937f ; **FLOATING
C1552 vss.n31 vss 0.00192f ; **FLOATING
C1553 vss.n32 vss 0.10937f ; **FLOATING
C1554 vss.n33 vss 0.00192f ; **FLOATING
C1555 vss.n34 vss 0.98429f ; **FLOATING
C1556 vss.n35 vss 0.10937f ; **FLOATING
C1557 vss.n36 vss 0.00955f ; **FLOATING
C1558 vss.n37 vss 0.15316f ; **FLOATING
C1559 vss.n38 vss 0.00955f ; **FLOATING
C1560 vss.n39 vss 0.15312f ; **FLOATING
C1561 vss.n40 vss 0.01078f ; **FLOATING
C1562 vss.n41 vss 0.00955f ; **FLOATING
C1563 vss.n42 vss 0.00955f ; **FLOATING
C1564 vss.n43 vss 0.15312f ; **FLOATING
C1565 vss.n44 vss 0.0082f ; **FLOATING
C1566 vss.n45 vss 0.01394f ; **FLOATING
C1567 vss.n46 vss 0.01394f ; **FLOATING
C1568 vss.n47 vss 0.02657f ; **FLOATING
C1569 vss.n48 vss 0.02788f ; **FLOATING
C1570 vss.n49 vss 0.01394f ; **FLOATING
C1571 vss.n50 vss 0.01394f ; **FLOATING
C1572 vss.n51 vss 0.01394f ; **FLOATING
C1573 vss.n52 vss 0.01394f ; **FLOATING
C1574 vss.n53 vss 0.01394f ; **FLOATING
C1575 vss.n54 vss 0.01394f ; **FLOATING
C1576 vss.n55 vss 0.01394f ; **FLOATING
C1577 vss.n56 vss 0.01394f ; **FLOATING
C1578 vss.n57 vss 0.01353f ; **FLOATING
C1579 vss.n58 vss 0.01078f ; **FLOATING
C1580 vss.n59 vss 0.00955f ; **FLOATING
C1581 vss.n60 vss 0.01078f ; **FLOATING
C1582 vss.n61 vss 0.00955f ; **FLOATING
C1583 vss.n62 vss 0.01078f ; **FLOATING
C1584 vss.n63 vss 0.00955f ; **FLOATING
C1585 vss.n64 vss 0.00895f ; **FLOATING
C1586 vss.n65 vss 0.02353f ; **FLOATING
C1587 vss.n66 vss 0.03131f ; **FLOATING
C1588 vss.n67 vss 0.01907f ; **FLOATING
C1589 vss.n68 vss 0.01907f ; **FLOATING
C1590 vss.n69 vss 0.01907f ; **FLOATING
C1591 vss.n70 vss 0.29037f ; **FLOATING
C1592 vss.n71 vss 0.15357f ; **FLOATING
C1593 vss.n72 vss 0.01456f ; **FLOATING
C1594 vss.n73 vss 0.01476f ; **FLOATING
C1595 vss.n74 vss 0.01456f ; **FLOATING
C1596 vss.n75 vss 0.01456f ; **FLOATING
C1597 vss.n76 vss 0.01456f ; **FLOATING
C1598 vss.n77 vss 0.01476f ; **FLOATING
C1599 vss.n78 vss 0.01456f ; **FLOATING
C1600 vss.n79 vss 0.01456f ; **FLOATING
C1601 vss.n80 vss 0.01476f ; **FLOATING
C1602 vss.n81 vss 0.00193f ; **FLOATING
C1603 vss.n82 vss 0.01456f ; **FLOATING
C1604 vss.n83 vss 0.01456f ; **FLOATING
C1605 vss.n84 vss 0.02619f ; **FLOATING
C1606 vss.n85 vss 0.03279f ; **FLOATING
C1607 vss.n86 vss 0.02044f ; **FLOATING
C1608 vss.n87 vss 0.7558f ; **FLOATING
C1609 vss.n88 vss 0.15302f ; **FLOATING
C1610 vss.n89 vss 0.98429f ; **FLOATING
C1611 vss.n90 vss 0.15312f ; **FLOATING
C1612 vss.n91 vss 0.98429f ; **FLOATING
C1613 vss.n92 vss 0.15312f ; **FLOATING
C1614 vss.n93 vss 0.98429f ; **FLOATING
C1615 vss.n94 vss 0.15312f ; **FLOATING
C1616 vss.n95 vss 0.01078f ; **FLOATING
C1617 vss.n96 vss 0.00955f ; **FLOATING
C1618 vss.n97 vss 0.01078f ; **FLOATING
C1619 vss.n98 vss 0.01078f ; **FLOATING
C1620 vss.n99 vss 0.00955f ; **FLOATING
C1621 vss.n100 vss 0.01078f ; **FLOATING
C1622 vss.n101 vss 0.01247f ; **FLOATING
C1623 vdd.n0 vss 0.01687f ; **FLOATING
C1624 vdd.n1 vss 0.01687f ; **FLOATING
C1625 vdd.n2 vss 0.13753f ; **FLOATING
C1626 vdd.n3 vss 0.15993f ; **FLOATING
C1627 vdd.n4 vss 0.03787f ; **FLOATING
C1628 vdd.n5 vss 0.01774f ; **FLOATING
C1629 vdd.n6 vss 0.01246f ; **FLOATING
C1630 vdd.n7 vss 0.00921f ; **FLOATING
C1631 vdd.n8 vss 0.01683f ; **FLOATING
C1632 m1_8353_17355# vss 33.66011f ; **FLOATING
C1633 m1_73167_71# vss 2.46316f ; **FLOATING
C1634 m1_67007_71# vss 16.88751f ; **FLOATING
C1635 vdd vss 84.11798f
C1636 m1_36693_17155# vss 3.78938f ; **FLOATING
C1637 m1_67727_71# vss 3.2515f ; **FLOATING
C1638 m1_67551_71# vss 16.94418f ; **FLOATING
C1639 m1_74255_71# vss 2.9961f ; **FLOATING
C1640 m1_68095_71# vss 16.94686f ; **FLOATING
C1641 a_64354_200# vss 49.07408f ; **FLOATING
C1642 trim0 vss 61.03913f
C1643 m1_68815_71# vss 3.17453f ; **FLOATING
C1644 m1_68639_71# vss 16.96625f ; **FLOATING
C1645 a_73058_200# vss 33.55874f ; **FLOATING
C1646 trim1 vss 45.27981f
C1647 m1_69183_71# vss 17.00439f ; **FLOATING
C1648 a_77410_200# vss 24.01607f ; **FLOATING
C1649 trim2 vss 36.18041f
C1650 a_79586_200# vss 18.84585f ; **FLOATING
C1651 trim3 vss 29.70176f
C1652 a_36760_18584# vss 81.06605f ; **FLOATING
C1653 m1_55_451# vss 6.45105f ; **FLOATING
C1654 a_122_1600# vss 0.14276p ; **FLOATING
C1655 m1_3775_451# vss 6.43713f ; **FLOATING
C1656 m1_7495_451# vss 6.64986f ; **FLOATING
C1657 m1_75343_71# vss 3.10406f ; **FLOATING
C1658 e8 vss 26.97667f ; **FLOATING
C1659 vg vss 46.28799f
C1660 m1_29815_451# vss 9.96005f ; **FLOATING
C1662 m1_14935_451# vss 6.66733f ; **FLOATING
C1663 m1_36887_451# vss 9.98483f ; **FLOATING
C1664 m1_76431_71# vss 2.94911f ; **FLOATING
C1665 m1_18655_451# vss 6.63485f ; **FLOATING
C1666 m1_43959_451# vss 10.73462f ; **FLOATING
C1667 m1_22375_451# vss 6.84476f ; **FLOATING
C1668 m1_66709_16605# vss 0.8856f ; **FLOATING
C1669 m1_81076_7276# vss 10.06675f ; **FLOATING
C1670 m1_77519_71# vss 3.04377f ; **FLOATING
C1671 a vss 0.15298p ; **FLOATING
C1672 m1_69293_16605# vss 0.79782f ; **FLOATING
C1673 m1_81556_7276# vss 10.06954f ; **FLOATING
C1674 m1_82036_7276# vss 10.0703f ; **FLOATING
C1675 m1_71877_16605# vss 0.7641f ; **FLOATING
C1676 m1_78607_71# vss 2.9114f ; **FLOATING
C1677 a_61534_200# vss 6.30401f ; **FLOATING
C1678 m1_82516_7276# vss 10.0817f ; **FLOATING
C1679 m1_74461_16605# vss 0.90978f ; **FLOATING
C1680 m1_82996_7276# vss 10.09279f ; **FLOATING
C1681 vref vss 2.57812f
C1682 m1_83476_7276# vss 10.10341f ; **FLOATING
C1683 e3 vss 10.14439f ; **FLOATING
C1684 m1_83956_7276# vss 10.31823f ; **FLOATING
C1685 m1_69903_71# vss 3.31715f ; **FLOATING
C1686 m1_69727_71# vss 17.04616f ; **FLOATING
C1687 m1_70271_71# vss 17.11568f ; **FLOATING
C1688 m1_64463_71# vss 3.14076f ; **FLOATING
C1689 m1_64287_71# vss 8.31574f ; **FLOATING
C1690 m1_70991_71# vss 0.77919f ; **FLOATING
C1691 m1_70815_71# vss 17.10507f ; **FLOATING
C1692 m1_64831_71# vss 1.21185f ; **FLOATING
C1693 m1_71359_71# vss 17.16085f ; **FLOATING
C1694 m1_65551_71# vss 3.1082f ; **FLOATING
C1695 m1_65375_71# vss 16.78213f ; **FLOATING
C1696 m1_72079_71# vss 3.22287f ; **FLOATING
C1697 m1_71903_71# vss 17.97862f ; **FLOATING
C1698 m1_65919_71# vss 16.80855f ; **FLOATING
C1699 m1_8861_17155# vss 3.79505f ; **FLOATING
C1700 a_58170_400# vss 12.71371f ; **FLOATING
C1701 m1_6169_17355# vss 14.69585f ; **FLOATING
C1702 m1_66639_71# vss 3.14687f ; **FLOATING
C1703 m1_66463_71# vss 16.84657f ; **FLOATING
XQQ1 vss vss a pnpMPA a=2e-12 p=6e-06
XQQ8 vss vss e8 pnpMPA a=2e-12 p=6e-06 m=8
XQQ3 vss vss e3 pnpMPA a=2e-12 p=6e-06
.ends
.subckt bandgap vref vg vdd vss trim3 trim2 trim1 trim0
X1 vss vg trim0 trim1 trim2 trim3 vref vdd bandgap_pex
.ends

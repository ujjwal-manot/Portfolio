* Extracted by KLayout with SG13G2 LVS runset on : 22/11/2026 14:17

.SUBCKT bandgap a e3 e8 trim0 trim1 trim2 trim3 vdd vg vref vss
M$1 \$2 \$3 \$3 vss sg13_hv_nmos L=8u W=16u AS=4.24p AD=4.24p PS=25.06u
+ PD=25.06u rfmode=0
M$3 \$4 \$3 \$2 vss sg13_hv_nmos L=8u W=16u AS=4.24p AD=4.24p PS=25.06u
+ PD=25.06u rfmode=0
M$5 \$5 \$3 \$4 vss sg13_hv_nmos L=8u W=16u AS=4.24p AD=4.24p PS=25.06u
+ PD=25.06u rfmode=0
M$7 vss \$3 \$5 vss sg13_hv_nmos L=8u W=16u AS=4.24p AD=4.24p PS=25.06u
+ PD=25.06u rfmode=0
M$9 \$6 \$3 \$193 vss sg13_hv_nmos L=8u W=16u AS=4.24p AD=4.24p PS=25.06u
+ PD=25.06u rfmode=0
M$11 \$7 \$3 \$6 vss sg13_hv_nmos L=8u W=16u AS=4.24p AD=4.24p PS=25.06u
+ PD=25.06u rfmode=0
M$13 \$8 \$3 \$7 vss sg13_hv_nmos L=8u W=16u AS=4.24p AD=4.24p PS=25.06u
+ PD=25.06u rfmode=0
M$15 vss \$3 \$8 vss sg13_hv_nmos L=8u W=16u AS=4.24p AD=4.24p PS=25.06u
+ PD=25.06u rfmode=0
M$17 \$9 \$193 vg vss sg13_hv_nmos L=8u W=32u AS=7.28p AD=7.28p PS=41.82u
+ PD=41.82u rfmode=0
M$21 \$11 \$193 \$9 vss sg13_hv_nmos L=8u W=32u AS=7.28p AD=7.28p PS=41.82u
+ PD=41.82u rfmode=0
M$25 \$12 \$193 \$11 vss sg13_hv_nmos L=8u W=32u AS=7.28p AD=7.28p PS=41.82u
+ PD=41.82u rfmode=0
M$29 vss \$193 \$12 vss sg13_hv_nmos L=8u W=32u AS=7.28p AD=7.28p PS=41.82u
+ PD=41.82u rfmode=0
M$33 vss \$13 \$13 vss sg13_hv_nmos L=4u W=2u AS=0.68p AD=0.68p PS=4.68u
+ PD=4.68u rfmode=0
M$34 vss \$13 \$14 vss sg13_hv_nmos L=4u W=2u AS=0.68p AD=0.68p PS=4.68u
+ PD=4.68u rfmode=0
M$35 vss \$14 vg vss sg13_hv_nmos L=1u W=1u AS=0.34p AD=0.34p PS=2.68u PD=2.68u
+ rfmode=0
M$36 vss trim0 \$15 vss sg13_hv_nmos L=0.5u W=1u AS=0.34p AD=0.34p PS=2.68u
+ PD=2.68u rfmode=0
M$37 vss trim1 \$16 vss sg13_hv_nmos L=0.5u W=1u AS=0.34p AD=0.34p PS=2.68u
+ PD=2.68u rfmode=0
M$38 vss trim2 \$17 vss sg13_hv_nmos L=0.5u W=1u AS=0.34p AD=0.34p PS=2.68u
+ PD=2.68u rfmode=0
M$39 vss trim3 \$18 vss sg13_hv_nmos L=0.5u W=1u AS=0.34p AD=0.34p PS=2.68u
+ PD=2.68u rfmode=0
M$40 \$19 \$15 \$20 vss sg13_hv_nmos L=0.5u W=1u AS=0.34p AD=0.34p PS=2.68u
+ PD=2.68u rfmode=0
M$41 \$21 trim0 \$20 vss sg13_hv_nmos L=0.5u W=1u AS=0.34p AD=0.34p PS=2.68u
+ PD=2.68u rfmode=0
M$42 \$22 \$15 \$23 vss sg13_hv_nmos L=0.5u W=1u AS=0.34p AD=0.34p PS=2.68u
+ PD=2.68u rfmode=0
M$43 \$24 trim0 \$23 vss sg13_hv_nmos L=0.5u W=1u AS=0.34p AD=0.34p PS=2.68u
+ PD=2.68u rfmode=0
M$44 \$25 \$15 \$26 vss sg13_hv_nmos L=0.5u W=1u AS=0.34p AD=0.34p PS=2.68u
+ PD=2.68u rfmode=0
M$45 \$27 trim0 \$26 vss sg13_hv_nmos L=0.5u W=1u AS=0.34p AD=0.34p PS=2.68u
+ PD=2.68u rfmode=0
M$46 \$28 \$15 \$29 vss sg13_hv_nmos L=0.5u W=1u AS=0.34p AD=0.34p PS=2.68u
+ PD=2.68u rfmode=0
M$47 \$30 trim0 \$29 vss sg13_hv_nmos L=0.5u W=1u AS=0.34p AD=0.34p PS=2.68u
+ PD=2.68u rfmode=0
M$48 \$31 \$15 \$32 vss sg13_hv_nmos L=0.5u W=1u AS=0.34p AD=0.34p PS=2.68u
+ PD=2.68u rfmode=0
M$49 \$33 trim0 \$32 vss sg13_hv_nmos L=0.5u W=1u AS=0.34p AD=0.34p PS=2.68u
+ PD=2.68u rfmode=0
M$50 \$34 \$15 \$35 vss sg13_hv_nmos L=0.5u W=1u AS=0.34p AD=0.34p PS=2.68u
+ PD=2.68u rfmode=0
M$51 \$36 trim0 \$35 vss sg13_hv_nmos L=0.5u W=1u AS=0.34p AD=0.34p PS=2.68u
+ PD=2.68u rfmode=0
M$52 \$37 \$15 \$38 vss sg13_hv_nmos L=0.5u W=1u AS=0.34p AD=0.34p PS=2.68u
+ PD=2.68u rfmode=0
M$53 \$39 trim0 \$38 vss sg13_hv_nmos L=0.5u W=1u AS=0.34p AD=0.34p PS=2.68u
+ PD=2.68u rfmode=0
M$54 \$40 \$15 \$41 vss sg13_hv_nmos L=0.5u W=1u AS=0.34p AD=0.34p PS=2.68u
+ PD=2.68u rfmode=0
M$55 \$42 trim0 \$41 vss sg13_hv_nmos L=0.5u W=1u AS=0.34p AD=0.34p PS=2.68u
+ PD=2.68u rfmode=0
M$56 \$20 \$16 \$43 vss sg13_hv_nmos L=0.5u W=1u AS=0.34p AD=0.34p PS=2.68u
+ PD=2.68u rfmode=0
M$57 \$23 trim1 \$43 vss sg13_hv_nmos L=0.5u W=1u AS=0.34p AD=0.34p PS=2.68u
+ PD=2.68u rfmode=0
M$58 \$26 \$16 \$44 vss sg13_hv_nmos L=0.5u W=1u AS=0.34p AD=0.34p PS=2.68u
+ PD=2.68u rfmode=0
M$59 \$29 trim1 \$44 vss sg13_hv_nmos L=0.5u W=1u AS=0.34p AD=0.34p PS=2.68u
+ PD=2.68u rfmode=0
M$60 \$32 \$16 \$45 vss sg13_hv_nmos L=0.5u W=1u AS=0.34p AD=0.34p PS=2.68u
+ PD=2.68u rfmode=0
M$61 \$35 trim1 \$45 vss sg13_hv_nmos L=0.5u W=1u AS=0.34p AD=0.34p PS=2.68u
+ PD=2.68u rfmode=0
M$62 \$38 \$16 \$46 vss sg13_hv_nmos L=0.5u W=1u AS=0.34p AD=0.34p PS=2.68u
+ PD=2.68u rfmode=0
M$63 \$41 trim1 \$46 vss sg13_hv_nmos L=0.5u W=1u AS=0.34p AD=0.34p PS=2.68u
+ PD=2.68u rfmode=0
M$64 \$43 \$17 \$47 vss sg13_hv_nmos L=0.5u W=1u AS=0.34p AD=0.34p PS=2.68u
+ PD=2.68u rfmode=0
M$65 \$44 trim2 \$47 vss sg13_hv_nmos L=0.5u W=1u AS=0.34p AD=0.34p PS=2.68u
+ PD=2.68u rfmode=0
M$66 \$45 \$17 \$48 vss sg13_hv_nmos L=0.5u W=1u AS=0.34p AD=0.34p PS=2.68u
+ PD=2.68u rfmode=0
M$67 \$46 trim2 \$48 vss sg13_hv_nmos L=0.5u W=1u AS=0.34p AD=0.34p PS=2.68u
+ PD=2.68u rfmode=0
M$68 \$47 \$18 vref vss sg13_hv_nmos L=0.5u W=1u AS=0.34p AD=0.34p PS=2.68u
+ PD=2.68u rfmode=0
M$69 \$48 trim3 vref vss sg13_hv_nmos L=0.5u W=1u AS=0.34p AD=0.34p PS=2.68u
+ PD=2.68u rfmode=0
M$70 vdd vg a vdd sg13_hv_pmos L=8u W=8u AS=2.72p AD=2.72p PS=16.68u PD=16.68u
+ rfmode=0
M$71 vdd vg \$191 vdd sg13_hv_pmos L=8u W=8u AS=2.72p AD=2.72p PS=16.68u
+ PD=16.68u rfmode=0
M$72 vdd vg \$42 vdd sg13_hv_pmos L=8u W=8u AS=2.72p AD=2.72p PS=16.68u
+ PD=16.68u rfmode=0
M$73 vdd vg \$197 vdd sg13_hv_pmos L=8u W=8u AS=2.72p AD=2.72p PS=16.68u
+ PD=16.68u rfmode=0
M$74 \$196 a \$3 vdd sg13_hv_pmos L=8u W=80u AS=16.7p AD=16.7p PS=93.34u
+ PD=93.34u rfmode=0
M$82 \$197 a \$196 vdd sg13_hv_pmos L=8u W=80u AS=16.7p AD=16.7p PS=93.34u
+ PD=93.34u rfmode=0
M$90 \$198 \$191 \$193 vdd sg13_hv_pmos L=8u W=80u AS=16.7p AD=16.7p PS=93.34u
+ PD=93.34u rfmode=0
M$98 \$197 \$191 \$198 vdd sg13_hv_pmos L=8u W=80u AS=16.7p AD=16.7p PS=93.34u
+ PD=93.34u rfmode=0
M$106 vdd vg vg vdd sg13_hv_pmos L=8u W=8u AS=2.72p AD=2.72p PS=16.68u
+ PD=16.68u rfmode=0
M$107 \$199 vss \$14 vdd sg13_hv_pmos L=10u W=0.5u AS=0.17p AD=0.17p PS=1.68u
+ PD=1.68u rfmode=0
M$108 \$200 vss \$199 vdd sg13_hv_pmos L=10u W=0.5u AS=0.17p AD=0.17p PS=1.68u
+ PD=1.68u rfmode=0
M$109 \$192 vss \$200 vdd sg13_hv_pmos L=10u W=0.5u AS=0.17p AD=0.17p PS=1.68u
+ PD=1.68u rfmode=0
M$110 \$201 vss \$192 vdd sg13_hv_pmos L=10u W=0.5u AS=0.17p AD=0.17p PS=1.68u
+ PD=1.68u rfmode=0
M$111 vdd vss \$201 vdd sg13_hv_pmos L=10u W=0.5u AS=0.17p AD=0.17p PS=1.68u
+ PD=1.68u rfmode=0
M$112 vdd vg \$13 vdd sg13_hv_pmos L=8u W=8u AS=2.72p AD=2.72p PS=16.68u
+ PD=16.68u rfmode=0
M$113 vdd trim0 \$15 vdd sg13_hv_pmos L=0.5u W=2u AS=0.68p AD=0.68p PS=4.68u
+ PD=4.68u rfmode=0
M$114 vdd trim1 \$16 vdd sg13_hv_pmos L=0.5u W=2u AS=0.68p AD=0.68p PS=4.68u
+ PD=4.68u rfmode=0
M$115 vdd trim2 \$17 vdd sg13_hv_pmos L=0.5u W=2u AS=0.68p AD=0.68p PS=4.68u
+ PD=4.68u rfmode=0
M$116 vdd trim3 \$18 vdd sg13_hv_pmos L=0.5u W=2u AS=0.68p AD=0.68p PS=4.68u
+ PD=4.68u rfmode=0
Q$117 vss vss e8 pnpMPA A=2p P=6u m=8
Q$121 vss vss a pnpMPA A=2p P=6u m=1
Q$126 vss vss e3 pnpMPA A=2p P=6u m=1
R$127 \$191 e8 vss rppd w=1u l=40u ps=0u b=0 m=1
R$134 \$19 e3 vss rppd w=1u l=290u ps=0u b=0 m=1
R$136 \$21 \$19 vss rppd w=1u l=2u ps=0u b=0 m=1
R$137 \$22 \$21 vss rppd w=1u l=2u ps=0u b=0 m=1
R$138 \$24 \$22 vss rppd w=1u l=2u ps=0u b=0 m=1
R$139 \$25 \$24 vss rppd w=1u l=2u ps=0u b=0 m=1
R$140 \$27 \$25 vss rppd w=1u l=2u ps=0u b=0 m=1
R$141 \$28 \$27 vss rppd w=1u l=2u ps=0u b=0 m=1
R$142 \$30 \$28 vss rppd w=1u l=2u ps=0u b=0 m=1
R$143 \$31 \$30 vss rppd w=1u l=2u ps=0u b=0 m=1
R$144 \$33 \$31 vss rppd w=1u l=2u ps=0u b=0 m=1
R$145 \$34 \$33 vss rppd w=1u l=2u ps=0u b=0 m=1
R$146 \$36 \$34 vss rppd w=1u l=2u ps=0u b=0 m=1
R$147 \$37 \$36 vss rppd w=1u l=2u ps=0u b=0 m=1
R$148 \$39 \$37 vss rppd w=1u l=2u ps=0u b=0 m=1
R$149 \$40 \$39 vss rppd w=1u l=2u ps=0u b=0 m=1
R$150 \$42 \$40 vss rppd w=1u l=2u ps=0u b=0 m=1
C$151 \$193 vss cap_cmim w=20u l=20u A=400p P=80u m=1
.ENDS bandgap

* The ADC core that is laid out: the cap DAC with its switches and the comparator, joined as in tests/convert.cir (comparator inp on vcm, inn on the DAC top plate), with top brought out so the conversion test can record it.
.subckt adc_core top vin vcm vref_hi vref_lo samp d7 d6 d5 d4 d3 d2 d1 d0 cclk cmp cmpn vdd vss
XDAC top vin vcm vref_hi vref_lo samp d7 d6 d5 d4 d3 d2 d1 d0 vdd vss cap_dac
XCMP vcm top cclk cmp cmpn vdd vss comparator
.ends adc_core

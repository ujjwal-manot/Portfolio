* Measures the sampled thermal noise of the capacitor DAC (kT/C, the only noise the transient conversions leave out besides the comparator's, since ngspice's transient analysis carries no device noise): with samp held high, the top plate on vcm through its switch and every bottom plate on vin through its own switch, the trim units on vcm, the noise at the top plate is integrated from 1 Hz to 1 THz, far past every switch's corner, and its rms value, which the top switch freezes on the plate when it opens, is written to ktc.txt; corner, temperature and supply come from corner.inc.
.include corner.inc
.include cap_dac_sizes.inc
.include cap_dac.cir
VDD vdd 0 {vsupply}
VHI vref_hi 0 1.0
VLO vref_lo 0 0.2
VCM vcm 0 0.6
VIN vin 0 dc 0.6 ac 1
VSAMP samp 0 {vsupply}
XDAC top vin vcm vref_hi vref_lo samp 0 vdd 0 0 0 0 0 0 0 0 vdd vdd vdd vdd vdd vdd vdd 0 cap_dac_cal
.control
noise v(top) VIN dec 20 1 1e12
setplot noise2
let rms = onoise_total
echo "ktc_rms_v $&rms" > ktc.txt
quit
.endc
.end

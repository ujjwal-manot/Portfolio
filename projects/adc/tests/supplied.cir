* Converts the same coherent tone as convert.cir with the ADC powered the way the chip powers it: bandgap_ldo's bandgap and LDO from the 3.3 V supply make the 1.2 V rail, which is the ADC's vdd and the top of design/reference.cir's ladder (vref_hi, vcm, vref_lo), with the bandgap at the trim code bandgap_ldo found for this process corner (trim0 to trim3 in corner.inc, from its results/corners.log); the input sine rides on vcm seen through a 1 Mohm, 10 pF filter (10 us), as a front end referenced to vcm would centre it without following each kick on vcm; the same columns as convert.txt (after the same 8 calibration frames) plus the rail and the three references, then the seven trim bits, are written every 50 ns to convert.txt, and the 3.3 V supply's average power over the conversions after calibration (from 9.3 us) (integrated into a 1 F capacitor) and the input frequency to measure.txt; corner, temperature, supplies and trim come from corner.inc.
.include corner.inc
.option reltol=1e-5 vntol=1e-8
.include tone.inc
.include comparator_sizes.inc
.include cap_dac_sizes.inc
.include reference_sizes.inc
.include bandgap_sizes.inc
.include ldo_sizes.inc
.include comparator.cir
.include cap_dac.cir
.include reference.cir
.include bandgap.cir
.include ldo.cir
.option interp rshunt=1e13 method=gear
VSUP sup 0 {vsupply33}
VT3 tr3 0 {vsupply33 * trim3}
VT2 tr2 0 {vsupply33 * trim2}
VT1 tr1 0 {vsupply33 * trim1}
VT0 tr0 0 {vsupply33 * trim0}
XBG bg vg sup 0 tr3 tr2 tr1 tr0 bandgap
XLDO vdd vdd bg vg sup 0 ldo
XREF vdd vref_hi vcm vref_lo 0 reference
RF vcm vcmf 1meg
CF vcmf 0 10p
BIN vin 0 v = v(vcmf) + 0.4 * 10 ** (-0.5 / 20) * sin(2 * pi * k_tone * 1e6 / n_samples * time)
VCLK clk 0 pulse(0 {vsupply} 50n 50p 50p 49.95n 100n)
VRST rst 0 pwl(0 0 250n 0 251n {vsupply})
VRDY rdy 0 {vsupply}
AIN [clk rst cmp rdy] [dclk drst dcmp drdy] tobits
.model tobits adc_bridge(in_low={vsupply / 3} in_high={2 * vsupply / 3})
ASAR [dclk drst dcmp drdy] [dsamp dcclk d7 d6 d5 d4 d3 d2 d1 d0 dcal dk6 dk5 dk4 dk3 dk2 dk1 dk0 dvalid o7 o6 o5 o4 o3 o2 o1 o0 dlast dovf] null sar
.model sar d_cosim simulation="./sar_logic.so"
AOUT [dsamp dcclk d7 d6 d5 d4 d3 d2 d1 d0 dcal dk6 dk5 dk4 dk3 dk2 dk1 dk0 dvalid o7 o6 o5 o4 o3 o2 o1 o0] [samp cclk a7 a6 a5 a4 a3 a2 a1 a0 cal t6 t5 t4 t3 t2 t1 t0 valid b7 b6 b5 b4 b3 b2 b1 b0] tovolts
.model tovolts dac_bridge(out_low=0 out_high={vsupply} t_rise=50p t_fall=50p)
XDAC top vin vcm vref_hi vref_lo samp cal a7 a6 a5 a4 a3 a2 a1 a0 t6 t5 t4 t3 t2 t1 t0 vdd 0 cap_dac_cal
XCMP vcm top cclk cmp cmpn vdd 0 comparator
BESUP 0 e_sup i = time > 0 ? -v(sup) * i(VSUP) : 0
CESUP e_sup 0 1
RESUP e_sup 0 1e12
.tran 50n {(n_samples + 11) * 1u + 300n}
.control
run
let span = length(time) - 1
let window = time[span] - 9.3e-6
meas tran s0 find v(e_sup) at=9.3u
let p_sup = (v(e_sup)[span] - s0) / window
meas tran first when v(vin)=v(vcmf) rise=1
meas tran second when v(vin)=v(vcmf) rise=2
let fin = 1 / (second - first)
echo "p_sup_w $&p_sup fin_hz $&fin" > measure.txt
wrdata convert.txt v(valid) v(b7) v(b6) v(b5) v(b4) v(b3) v(b2) v(b1) v(b0) v(samp) v(vin) v(top) v(vcm) v(vdd) v(vref_hi) v(vref_lo) v(t6) v(t5) v(t4) v(t3) v(t2) v(t1) v(t0)
quit
.endc
.end

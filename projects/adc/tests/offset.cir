* Finds the comparator's switching threshold by bisection (15 halvings of a +-20 mV range, about 1 uV) twice: once with the previous decision forced low by a -50 mV first clock, once forced high by +50 mV, and writes both thresholds, their mean (the offset) and their difference (the hysteresis the last decision leaves) to offset.txt, solved to a relative tolerance of 1e-5 (the default 1e-3 is 0.6 mV on a 0.6 V node, a fifth of an LSB); corner, temperature, supply and mismatch come from corner.inc.
.include corner.inc
.option reltol=1e-5 vntol=1e-8
.include comparator_sizes.inc
.include dut.cir
VDD vdd 0 {vsupply}
VCLK clk 0 pulse(0 {vsupply} 5n 50p 50p 9.95n 20n)
VD d 0 pwl(0 -50m 15n -50m 15.1n 0 40n 0)
EP inp 0 vol='0.6 + v(d)/2'
EN inn 0 vol='0.6 - v(d)/2'
XC inp inn clk outp outn vdd 0 comparator
CLP outp 0 5f
CLN outn 0 5f
.control
let nan = 1e400 - 1e400
let found = vector(2)
let side = 0
foreach first -50e-3 50e-3
  let lo = -20e-3
  let hi = 20e-3
  repeat 15
    let mid = (lo + hi) / 2
    alter @VD[pwl] = [ 0 $first 15e-9 $first 15.1e-9 $&mid 40e-9 $&mid ]
    tran 10p 40n
    let op = nan
    meas tran op find v(outp) at=38n
    if op > 0.6
      let hi = mid
    else
      let lo = mid
    end
    let lo = lo + op - op
    let hi = hi + op - op
  end
  let found[side] = (lo + hi) / 2
  let side = side + 1
end
let up = found[0]
let down = found[1]
let offset = (up + down) / 2
let hysteresis = up - down
echo "offset_v $&offset hysteresis_v $&hysteresis up_v $&up down_v $&down" > offset.txt
quit
.endc
.end

* Converts a slow staircase with the same transistor DAC, comparator, co-simulated sar_logic and solver settings as convert.cir, after the same 8 calibration frames: ramp.inc (written by adc_ramp.py) holds vin steady through each sample and steps it 1/8 LSB per conversion, over 200 ns halfway through the bit trials, across 5 LSB around each of the major code transitions 64, 128 and 192, and time, m_tvalid, the eight m_tdata bits, samp, vin, the top plate, vcm and the seven trim bits are written every 50 ns to ramp.txt; corner, temperature, supply and mismatch come from corner.inc.
.include corner.inc
.option reltol=1e-5 vntol=1e-8
.include ramp.inc
.include comparator_sizes.inc
.include cap_dac_sizes.inc
.include comparator.cir
.include cap_dac.cir
.option interp rshunt=1e13 method=gear
VDD vdd 0 {vsupply}
VHI vref_hi 0 1.0
VLO vref_lo 0 0.2
VCM vcm 0 0.6
VCLK clk 0 pulse(0 {vsupply} 50n 50p 50p 49.95n 100n)
VRST rst 0 pwl(0 0 250n 0 251n {vsupply})
VRDY rdy 0 {vsupply}
AIN [clk rst cmp rdy] [dclk drst dcmp drdy] tobits
.model tobits adc_bridge(in_low={vsupply / 3} in_high={2 * vsupply / 3})
ASAR [dclk drst dcmp drdy] [dsamp dcclk d7 d6 d5 d4 d3 d2 d1 d0 dcal dk6 dk5 dk4 dk3 dk2 dk1 dk0 dvalid o7 o6 o5 o4 o3 o2 o1 o0 dlast dovf] null sar
.model sar d_cosim simulation="./sar_logic.so"
AOUT [dsamp dcclk d7 d6 d5 d4 d3 d2 d1 d0 dcal dk6 dk5 dk4 dk3 dk2 dk1 dk0 dvalid o7 o6 o5 o4 o3 o2 o1 o0] [samp cclk a7 a6 a5 a4 a3 a2 a1 a0 cal t6 t5 t4 t3 t2 t1 t0 valid b7 b6 b5 b4 b3 b2 b1 b0] tovolts
.model tovolts dac_bridge(out_low=0 out_high={vsupply} t_rise=50p t_fall=50p)
XDAC top vin vcm vref_hi vref_lo samp cal a7 a6 a5 a4 a3 a2 a1 a0 t6 t5 t4 t3 t2 t1 t0 vdd 0 cap_dac_cal
XCMP vcm top cclk cmp cmpn vdd 0 comparator
.tran 50n {ramp_end}
.control
run
wrdata ramp.txt v(valid) v(b7) v(b6) v(b5) v(b4) v(b3) v(b2) v(b1) v(b0) v(samp) v(vin) v(top) v(vcm) v(t6) v(t5) v(t4) v(t3) v(t2) v(t1) v(t0)
quit
.endc
.end

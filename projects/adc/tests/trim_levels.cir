* Measures the top-plate offset trim the way calibration uses it: with cal high the DAC samples its own 0x80 level (150 ns of each 300 ns step), then for each of the 128 trim codes (seven pulse sources counting in binary) the top plate's distance from vcm at the end of the step is written to trim_levels.txt; a second run holds the trim at code 63 and, after every second sample, moves the DAC from the sampled 0x80 to 0x81, and the top plate after a sample left at 0x80 and after the next one moved to 0x81 is written for eight such pairs, whose mean difference adc_trim.py takes as dac_step_v (one DAC LSB as the comparator sees it, attenuated by the trim and every other top-plate capacitance, with the top switch's charge injection common to both and so cancelled), so the trim can be read in LSB; starts without an operating point like dac_levels.cir, solved to a relative tolerance of 1e-5; corner, temperature, supply and mismatch come from corner.inc.
.include corner.inc
.option reltol=1e-5 vntol=1e-8
.include cap_dac_sizes.inc
.include cap_dac.cir
.param t0=300n dwell=300n
VDD vdd 0 {vsupply}
VHI vref_hi 0 1.0
VLO vref_lo 0 0.2
VCM vcm 0 0.6
VMODE mode 0 0
VSAMP samp 0 pulse(0 {vsupply} {t0} 50p 50p {dwell / 2} {dwell})
VAFTER after 0 pulse(0 {vsupply} {t0 + 1.5 * dwell + 2n} 50p 50p {dwell / 2 - 4n} {2 * dwell})
V0 c0 0 pulse(0 {vsupply} {t0 + dwell} 50p 50p {dwell - 50p} {2 * dwell})
V1 c1 0 pulse(0 {vsupply} {t0 + 2 * dwell} 50p 50p {2 * dwell - 50p} {4 * dwell})
V2 c2 0 pulse(0 {vsupply} {t0 + 4 * dwell} 50p 50p {4 * dwell - 50p} {8 * dwell})
V3 c3 0 pulse(0 {vsupply} {t0 + 8 * dwell} 50p 50p {8 * dwell - 50p} {16 * dwell})
V4 c4 0 pulse(0 {vsupply} {t0 + 16 * dwell} 50p 50p {16 * dwell - 50p} {32 * dwell})
V5 c5 0 pulse(0 {vsupply} {t0 + 32 * dwell} 50p 50p {32 * dwell - 50p} {64 * dwell})
V6 c6 0 pulse(0 {vsupply} {t0 + 64 * dwell} 50p 50p {64 * dwell - 50p} {128 * dwell})
BT0 t0 0 v = v(mode) > 0.5 ? {vsupply} : v(c0)
BT1 t1 0 v = v(mode) > 0.5 ? {vsupply} : v(c1)
BT2 t2 0 v = v(mode) > 0.5 ? {vsupply} : v(c2)
BT3 t3 0 v = v(mode) > 0.5 ? {vsupply} : v(c3)
BT4 t4 0 v = v(mode) > 0.5 ? {vsupply} : v(c4)
BT5 t5 0 v = v(mode) > 0.5 ? {vsupply} : v(c5)
BT6 t6 0 v = v(mode) > 0.5 ? 0 : v(c6)
BD0 d0 0 v = v(mode) > 0.5 ? v(after) : 0
VCAL cal 0 {vsupply}
XDAC top vin vcm vref_hi vref_lo samp cal vdd 0 0 0 0 0 0 d0 t6 t5 t4 t3 t2 t1 t0 vdd 0 cap_dac_cal
VIN vin 0 0.6
.control
let nan = 1e400 - 1e400
tran 1n 38.7u uic
echo "code shift_v" > trim_levels.txt
echo "zero is real: code (trim codes are numbered from 0, the first with every trim bit low)" >> trim_levels.txt
let code = 0
while code < 128
  let at = 300e-9 + (code + 0.95) * 300e-9
  let level = nan
  meas tran level find v(top) at=$&at
  let err = level - 0.6
  echo "$&code $&err" >> trim_levels.txt
  let code = code + 1
end
alter VMODE dc = 1
tran 1n 5.4u uic
let k = 0
while k < 8
  let at = 300e-9 + (2 * k + 0.95) * 300e-9
  let a = nan
  meas tran a find v(top) at=$&at
  let at = 300e-9 + (2 * k + 1.95) * 300e-9
  let b = nan
  meas tran b find v(top) at=$&at
  echo "pair_$&k $&a $&b" >> trim_levels.txt
  let k = k + 1
end
quit
.endc
.end

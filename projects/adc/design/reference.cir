* ADC references from the 1.2 V analog rail: six identical rppd units from vtop to ground give vref_hi, vcm and vref_lo at 5/6, 3/6 and 1/6 of it (1.0, 0.6 and 0.2 V from 1.2 V); the DAC draws charge from vref_hi and returns about as much into vref_lo, so the main decoupling is thin-oxide NMOS gate capacitance from vref_hi (gate) to vref_lo (channel, 0.8 V across it, well in inversion), more from vref_hi to ground holds the pair's common mode, which the top plate follows, and vcm, which holds the top plate and takes the comparator's kickback, gets its own NMOS gate capacitance to ground (0.6 V on the gate); the sizes came from 20 us runs of tests/supplied.cir reading the references at each comparator decision.
.subckt reference vtop vref_hi vcm vref_lo vss
XR5 vtop vref_hi vss rppd w={w_lad} l={l_lad} mm_ok={mm}
XR4 vref_hi n4 vss rppd w={w_lad} l={l_lad} mm_ok={mm}
XR3 n4 vcm vss rppd w={w_lad} l={l_lad} mm_ok={mm}
XR2 vcm n2 vss rppd w={w_lad} l={l_lad} mm_ok={mm}
XR1 n2 vref_lo vss rppd w={w_lad} l={l_lad} mm_ok={mm}
XR0 vref_lo vss vss rppd w={w_lad} l={l_lad} mm_ok={mm}
XCHL vref_lo vref_hi vref_lo vss sg13_lv_nmos w=10u l=10u m={m_hl} mm_ok={mm}
XCH vss vref_hi vss vss sg13_lv_nmos w=10u l=10u m={m_h} mm_ok={mm}
XCCM vss vcm vss vss sg13_lv_nmos w=10u l=10u m={m_cm} mm_ok={mm}
.ends
